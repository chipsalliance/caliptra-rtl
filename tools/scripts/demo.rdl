addrmap top {
    desc="rdl demo";

    signal {activelow; async; cpuif_reset;} reset_b;
    signal {activehigh;} prot_wr;

    default hw = na;
    
    reg some_reg { field {} a; };

//address generation examples
    regfile {
        some_reg a @0x0;
        some_reg b @0x4;
        some_reg c; // Implies address of 8
                    // Address 0xC is not implemented or specified
        some_reg d @0x10;

        some_reg e[10]; // So these will consume 40 bytes
                        // Address 0,4,8,C....
        some_reg f[10] @0x100 += 0x10; // These consume 160-12 bytes of space

        some_reg g[10]; // So these will consume 40 bytes
                        // Address 0,4,8,C....
        some_reg h[10] @0x200 += 0x10; // These consume 160-12 bytes of space
                                       // Address 0x100 to 0x103, 0x110 to 0x113,....
        some_reg i %=0x80; // This means ((address % 0x80) == 0))
                           // So this would imply an address of 0x200 since
                           // that is the first address satisfying address>=0x194
                           // and ((address % 0x80) == 0)
    } example_regfile1;

//component properties
    field ex1 {sw = rw; hw = r;};
    field ex2 {sw = w; hw = r;};

    field ex3 {
        rset; //set on read, implicit true
        swwe = prot_wr;
    };

    reg {
        field {} def1;
        ex1 ex_field1[2];
        ex2 ex_field2[10:5];
        field {} def2[15:13];
        ex3 ex_field3[31:29];
    } example_reg1;
};