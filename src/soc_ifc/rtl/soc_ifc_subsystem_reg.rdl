// SPDX-License-Identifier: Apache-2.0
//
// Licensed under the Apache License, Version 2.0 (the "License");
// you may not use this file except in compliance with the License.
// You may obtain a copy of the License at
//
// http://www.apache.org/licenses/LICENSE-2.0
//
// Unless required by applicable law or agreed to in writing, software
// distributed under the License is distributed on an "AS IS" BASIS,
// WITHOUT WARRANTIES OR CONDITIONS OF ANY KIND, either express or implied.
// See the License for the specific language governing permissions and
// limitations under the License.
//
////////////////////////////////////////////////////////////////
// Subsystem Straps and Registers

field strap { sw=r; hw=w; };

reg {
    name = "Subsystem SoC Interface Base Address (Low)";
    desc = "Subsystem SoC Interface Base Address Lower 32 bits (from AXI)
            [br]Caliptra Access: RO
            [br]SOC Access:      RO";
    strap addr_l[32];
} SS_SOC_IFC_BASE_ADDR_L @0x500;

reg {
    name = "Subsystem SoC Interface Base Address (High)";
    desc = "Subsystem SoC Interface Base Address Upper 32 bits (from AXI)
            [br]Caliptra Access: RO
            [br]SOC Access:      RO";
    strap addr_h[32];
} SS_SOC_IFC_BASE_ADDR_H;

reg {
    name = "Subsystem MCI Base Address (Low)";
    desc = "Subsystem MCI Base Address Lower 32 bits (from AXI)
            [br]Caliptra Access: RO
            [br]SOC Access:      RO";
    strap addr_l[32];
} SS_MCI_BASE_ADDR_L;

reg {
    name = "Subsystem MCI Base Address (High)";
    desc = "Subsystem MCI Base Address Upper 32 bits (from AXI)
            [br]Caliptra Access: RO
            [br]SOC Access:      RO";
    strap addr_h[32];
} SS_MCI_BASE_ADDR_H;

reg {
    name = "Subsystem Recovery Interface Base Address (Low)";
    desc = "Subsystem Recovery Interface Base Address Lower 32 bits (from AXI)
            [br]Caliptra Access: RO
            [br]SOC Access:      RO";
    strap addr_l[32];
} SS_RECOVERY_IFC_BASE_ADDR_L;

reg {
    name = "Subsystem Recovery Interface Base Address (High)";
    desc = "Subsystem Recovery Interface Base Address Upper 32 bits (from AXI)
            [br]Caliptra Access: RO
            [br]SOC Access:      RO";
    strap addr_h[32];
} SS_RECOVERY_IFC_BASE_ADDR_H;

reg {
    name = "Subsystem Fuse Controller Base Address (Low)";
    desc = "Subsystem Fuse Controller Base Address Lower 32 bits (from AXI)
            [br]Caliptra Access: RO
            [br]SOC Access:      RO";
    strap addr_l[32];
} SS_OTP_FC_BASE_ADDR_L;

reg {
    name = "Subsystem Fuse Controller Base Address (High)";
    desc = "Subsystem Fuse Controller Base Address Upper 32 bits (from AXI)
            [br]Caliptra Access: RO
            [br]SOC Access:      RO";
    strap addr_h[32];
} SS_OTP_FC_BASE_ADDR_H;

reg {
    name = "Subsystem UDS Seed Destination Base Address (Low)";
    desc = "Subsystem UDS Seed Destination Base Address Lower 32 bits (from AXI). Used as the write address when programming the UDS seed during manufacturing.
            [br]Caliptra Access: RO
            [br]SOC Access:      RO";
    strap addr_l[32];
} SS_UDS_SEED_BASE_ADDR_L;

reg {
    name = "Subsystem UDS Seed Destination Base Address (High)";
    desc = "Subsystem UDS Seed Destination Base Address Upper 32 bits (from AXI). Used as the write address when programming the UDS seed during manufacturing.
            [br]Caliptra Access: RO
            [br]SOC Access:      RO";
    strap addr_h[32];
} SS_UDS_SEED_BASE_ADDR_H;

reg {
    name = "Subsystem SoC Nonce";
    desc = "TODO Need a register that needs a fixed NONCE (this is a register (not a fuse from Caliptra POV) that MCU can write)"; // TODO
    field { sw=rw; hw=r; resetsignal = cptra_rst_b; } nonce[32]=0;
} SS_SOC_NONCE[16] @0x560;

reg {
    name = "DEBUG INTENT";
    desc = "Strap from SoC in Subsystem configuration that indicates if this boot cycle will be used for debug.
            [br]Caliptra Access: RO
            [br]SOC Access:      RO";
    strap debug_intent;
} SS_DEBUG_INTENT;

reg {
    name = "RESERVED STRAP";
    desc = "Straps reserved for late-binding features for survivability.
            [br]Caliptra Access: RO
            [br]SOC Access:      RO";
    strap rsvd[32];
} SS_STRAP_RSVD[4] @0x5c0;

reg {
    name = "SUBSYSTEM DEBUG & MANUF SERVICE REG REQUEST";
    desc = "JTAG in debug/manuf mode or SOC can write to this register for ROM/FW defined skips or services.
            [br]This register is used to support Subsystem flows, and is disabled in Caliptra passive mode.
            [br]Caliptra Access: RW
            [br]SOC Access:      RW
            [br]TAP Access [in debug/manuf mode]: RW";
    field {desc="Manufacturing debug unlock request. Only writable when lifecycle state is MANUFACTURING and DEBUG_INTENT strap is set to 1."; sw=rw; hw=rw; swwe=true; we=true; resetsignal = cptra_rst_b;} MANUF_DBG_UNLOCK_REQ = 1'b0;
    field {desc="Production debug unlock request. Only writable when lifecycle state is PRODUCTION and DEBUG_INTENT strap is set to 1."      ; sw=rw; hw=rw; swwe=true; we=true; resetsignal = cptra_rst_b;} PROD_DBG_UNLOCK_REQ = 1'b0;
    field {desc="UDS programming request. Only writable when lifecycle state is MANUFACTURING."                                              ; sw=rw; hw=rw; swwe=true; we=true; resetsignal = cptra_rst_b;} UDS_PROGRAM_REQ = 1'b0;
} SS_DBG_MANUF_SERVICE_REG_REQ @0x5e0;

reg {
    name = "SUBSYSTEM DEBUG & MANUF SERVICE REG RESPONSE";
    desc = "JTAG in debug/manuf mode or SOC can read from this register for ROM/FW defined skips or services.
            [br]This register is used to support Subsystem flows, and is disabled in Caliptra passive mode.
            [br]Caliptra Access: RW
            [br]SOC Access:      RO
            [br]TAP Access [in debug/manuf mode]: RO";
    field {desc="Manufacturing debug unlock was successful. Only writable by Caliptra, and only when lifecycle state is MANUFACTURING and DEBUG_INTENT strap is set to 1. Sticky once set, until warm reset."; sw=rw; hw=rw; swwe=true; resetsignal = cptra_rst_b;} MANUF_DBG_UNLOCK_SUCCESS     = 1'b0;
    field {desc="Manufacturing debug unlock failed. Only writable by Caliptra, and only when lifecycle state is MANUFACTURING and DEBUG_INTENT strap is set to 1."                                           ; sw=rw; hw=rw; swwe=true; resetsignal = cptra_rst_b;} MANUF_DBG_UNLOCK_FAIL        = 1'b0;
    field {desc="Manufacturing debug unlock is in progress. Only writable by Caliptra, and only when lifecycle state is MANUFACTURING and DEBUG_INTENT strap is set to 1."                                   ; sw=rw; hw=rw; swwe=true; resetsignal = cptra_rst_b;} MANUF_DBG_UNLOCK_IN_PROGRESS = 1'b0;
    field {desc="Production debug unlock was successful. Only writable by Caliptra, and only when lifecycle state is PRODUCTION and DEBUG_INTENT strap is set to 1. Sticky once set, until warm reset."      ; sw=rw; hw=rw; swwe=true; resetsignal = cptra_rst_b;} PROD_DBG_UNLOCK_SUCCESS      = 1'b0;
    field {desc="Production debug unlock failed. Only writable by Caliptra, and only when lifecycle state is PRODUCTION and DEBUG_INTENT strap is set to 1."                                                 ; sw=rw; hw=rw; swwe=true; resetsignal = cptra_rst_b;} PROD_DBG_UNLOCK_FAIL         = 1'b0;
    field {desc="Production debug unlock is in progress. Only writable by Caliptra, and only when lifecycle state is PRODUCTION and DEBUG_INTENT strap is set to 1."                                         ; sw=rw; hw=rw; swwe=true; resetsignal = cptra_rst_b;} PROD_DBG_UNLOCK_IN_PROGRESS  = 1'b0;
    field {desc="UDS Programming was successful. Only writable by Caliptra, and only when lifecycle state is MANUFACTURING. Sticky once set, until warm reset."                                              ; sw=rw; hw=rw; swwe=true; resetsignal = cptra_rst_b;} UDS_PROGRAM_SUCCESS          = 1'b0;
    field {desc="UDS Programming failed. Only writable by Caliptra, and only when lifecycle state is MANUFACTURING."                                                                                         ; sw=rw; hw=rw; swwe=true; resetsignal = cptra_rst_b;} UDS_PROGRAM_FAIL             = 1'b0;
    field {desc="UDS Programming is in progress. Only writable by Caliptra, and only when lifecycle state is MANUFACTURING."                                                                                 ; sw=rw; hw=rw; swwe=true; resetsignal = cptra_rst_b;} UDS_PROGRAM_IN_PROGRESS      = 1'b0;
} SS_DBG_MANUF_SERVICE_REG_RSP;

reg {
    name = "SUBSYSTEM SOC DEBUG UNLOCK LEVEL";
    desc = "Individual bits indicating debug unlock level to multiple SoC endpoints.
            [br]This register is used to support Subsystem flows, and is disabled in Caliptra passive mode.
            [br]Caliptra Access: RW
            [br]SOC Access:      RO
            [br]TAP Access [in debug/manuf mode]: RO";
    field {desc="Debug unlock level"; sw=rw; } LEVEL[32] = 32'h0;
} SS_SOC_DBG_UNLOCK_LEVEL;
