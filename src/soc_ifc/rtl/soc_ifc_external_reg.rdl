// SPDX-License-Identifier: Apache-2.0
//
// Licensed under the Apache License, Version 2.0 (the "License");
// you may not use this file except in compliance with the License.
// You may obtain a copy of the License at
//
// http://www.apache.org/licenses/LICENSE-2.0
//
// Unless required by applicable law or agreed to in writing, software
// distributed under the License is distributed on an "AS IS" BASIS,
// WITHOUT WARRANTIES OR CONDITIONS OF ANY KIND, either express or implied.
// See the License for the specific language governing permissions and
// limitations under the License.
//
////////////////////////////////////////////////////////////////
// SOC-Facing Registers
reg {
    name = "Hardware Error Fatal";
    desc = "Indicates fatal hardware error. Assertion of any bit in this
            register results in the assertion of the SoC interrupt pin,
            cptra_error_fatal, unless that bit is masked using the internal
            mask register. After the output interrupt is asserted, clearing
            the bit in this register will not cause the interrupt to deassert.
            Only a Caliptra reset will clear the fatal error interrupt.
            [br]Caliptra Access: RW1C
            [br]SOC Access:      RW1C";
    rw_rw_sticky_hw iccm_ecc_unc=0;     /* Uncorrectable double-bit error in ICCM */
    rw_rw_sticky_hw dccm_ecc_unc=0;     /* Uncorrectable double-bit error in DCCM */
    rw_rw_sticky_hw nmi_pin=0;          /* Non-Maskable Interrupt due to WDT timeout */
} CPTRA_HW_ERROR_FATAL;
reg {
    name = "Hardware Error Non-Fatal";
    desc = "Indicates non-fatal hardware error. Assertion of any bit in this
            register results in the assertion of the SoC interrupt pin,
            cptra_error_non_fatal, unless that bit is masked using the internal
            mask register. After the output interrupt is asserted, any
            change by firmware that results in all set non-fatal errors
            being masked will immediately deassert the interrupt output. This means
            that firmware may cause the cptra_error_non_fatal signal to deassert by
            writing to any of these registers, if the write results in all error
            bits being cleared or masked:
            [br][list]
            [br] [*] CPTRA_HW_ERROR_NON_FATAL
            [br] [*] CPTRA_FW_ERROR_NON_FATAL
            [br] [*] internal_hw_error_non_fatal_mask
            [br] [*] internal_fw_error_non_fatal_mask 
            [/list]
            [br]Caliptra Access: RW1C
            [br]SOC Access:      RW1C";
    rw_rw_sticky_hw mbox_prot_no_lock=0; /* SOC access while not locked */
    rw_rw_sticky_hw mbox_prot_ooo=0;     /* Register access out-of-order */
    rw_rw_sticky_hw mbox_ecc_unc=0;      /* Uncorrectable double-bit error in DCCM */
} CPTRA_HW_ERROR_NON_FATAL;
reg {
    name = "Firmware Error Fatal";
    desc = "Indicates fatal firmware error. Assertion of any bit in this
            register results in the assertion of the SoC interrupt pin,
            cptra_error_fatal, unless that bit is masked using the internal
            mask register. After the output interrupt is asserted, clearing
            the bit in this register will not cause the interrupt to deassert.
            Only a Caliptra reset will clear the fatal error interrupt.
            [br]Caliptra Access: RW
            [br]SOC Access:      RW";
    rw_rw_sticky error_code[32]=0; 
} CPTRA_FW_ERROR_FATAL;
reg {
    name = "Firmware Error Non-Fatal";
    desc = "Indicates non-fatal firmware error. Assertion of any bit in this
            register results in the assertion of the SoC interrupt pin,
            cptra_error_non_fatal, unless that bit is masked using the internal
            mask register. After the output interrupt is asserted, any
            change by firmware that results in all set non-fatal errors
            being masked will immediately deassert the interrupt output. This means
            that firmware may cause the cptra_error_non_fatal signal to deassert by
            writing to any of these registers, if the write results in all error
            bits being cleared or masked:
            [br][list]
            [br] [*] CPTRA_HW_ERROR_NON_FATAL
            [br] [*] CPTRA_FW_ERROR_NON_FATAL
            [br] [*] internal_hw_error_non_fatal_mask
            [br] [*] internal_fw_error_non_fatal_mask
            [/list]
            [br]Caliptra Access: RW
            [br]SOC Access:      RW";
    rw_rw_sticky error_code[32]=0; 
} CPTRA_FW_ERROR_NON_FATAL;
reg {
    name = "Hardware Error Encoding";
    desc = "Encoded error value for hardware errors.
            [br]Caliptra Access: RW
            [br]SOC Access:      RW
            [br]TAP Access [in debug/manuf mode]: RO";
     field {resetsignal = cptra_pwrgood; hw=r;}error_code[32]=0; 
} CPTRA_HW_ERROR_ENC;
reg {
    name = "Firmware Error Encoding";
    desc = "Encoded error value for firmware errors.
            [br]Caliptra Access: RW
            [br]SOC Access:      RW
            [br]TAP Access [in debug/manuf mode]: RO";
    field {resetsignal = cptra_pwrgood; hw=r;} error_code[32]=0; 
} CPTRA_FW_ERROR_ENC;
reg {
    name = "Firmware Extended Error Information";
    desc = "Firmware Extended Error information for firmware errors.
            [br]Caliptra Access: RW
            [br]SOC Access:      RW";
    field {resetsignal = cptra_pwrgood; hw=r;} error_info[32]=0; 
} CPTRA_FW_EXTENDED_ERROR_INFO[8];
reg {
    name = "Boot Status";
    desc = "Reports the boot status.
            [br]Caliptra Access: RW
            [br]SOC Access:      RO
            [br]TAP Access [in debug/manuf mode]: RO";
    field {swwel = soc_req; hw=r; resetsignal = cptra_rst_b;} status[32]=0;
} CPTRA_BOOT_STATUS;
reg {
    name = "Flow Status";
    desc = "Reports the status of the firmware flows.
            [br]Caliptra Access: RW
            [br]SOC Access:      RO";
    rw_ro status[24]=0;
    field {desc="DEV ID CSR ready";                                          sw=rw; swwel = soc_req; hw=r ; resetsignal = cptra_rst_b;} idevid_csr_ready[1]=0;
    field {desc="Boot FSM State";                                            sw=r;                   hw=w ; /* no storage, no reset */} boot_fsm_ps[3];
    field {desc="Indicates Caliptra is ready for Firmware Download";         sw=rw; swwel = soc_req; hw=r ; resetsignal = cptra_rst_b;} ready_for_fw[1]=0;
    field {desc="Indicates Caliptra is ready for RT flows";                  sw=rw; swwel = soc_req; hw=r ; resetsignal = cptra_rst_b;} ready_for_runtime[1]=0;
    field {desc="Indicates Caliptra is ready for Fuses to be programmed.
                 Read-only to both Caliptra and SOC.";                       sw=r;                   hw=w ; /* no storage, no reset */} ready_for_fuses[1];
    field {desc="Indicates Caliptra is has completed Mailbox Flow.";         sw=rw; swwel = soc_req; hw=r ; resetsignal = cptra_rst_b;} mailbox_flow_done[1]=0;
} CPTRA_FLOW_STATUS;
reg {
    name = "Reset Reason";
    desc = "Indicates to ROM the originating cause for the PC to be reset to 0.
            Only reset during cold-boot (sticky).
            [br]Caliptra Access: RO
            [br]SOC Access:      RO";
    field {desc = "FW update reset has been executed"; sw=r; hw=rw; we=true; resetsignal = cptra_rst_b;}      FW_UPD_RESET=0;
    field {desc = "warm reset has been executed";      sw=r; hw=rw; resetsignal = cptra_pwrgood;} WARM_RESET=0;
} CPTRA_RESET_REASON;

reg {
    name = "Security State";
    desc = "Indicates current hardware security state.
            [br]Caliptra Access: RO
            [br]SOC Access:      RO";
    enum device_lifecycle_e {
        DEVICE_UNPROVISIONED = 2'b00 {
            desc = "Unprovisioned";
        };
        DEVICE_MANUFACTURING = 2'b01 {
            desc = "Manufacturing";
        };
        DEVICE_PRODUCTION    = 2'b11 {
            desc = "Production";
        };
    };
    field {desc = "Device Lifecycle"; sw=r; hw=w; encode = device_lifecycle_e; resetsignal = cptra_rst_b;} device_lifecycle[2]=0;
    field {desc = "Debug Locked"    ; sw=r; hw=w;                              resetsignal = cptra_rst_b;} debug_locked=0;
    field {desc = "scan mode signal observed at caliptra interface - only for debug mode as its used to flush assets - 
                   when truly in scan mode, everything will be BROKEN for functional reads!"; 
                                      sw=r; hw=w;                              resetsignal = cptra_rst_b;} scan_mode=0;
    field {desc = "Reserved field"  ; sw=r;                                    resetsignal = cptra_rst_b;} rsvd[28] = 0;
} CPTRA_SECURITY_STATE;

reg {
    name = "Valid User Registers";
     desc = "Valid PAUSER attributes for requests from SoC APB Interface. Only valid once LOCK is set.
             [br]Caliptra Access: RW
             [br]SOC Access:      RW
             Read-Only once locked by PAUSER_LOCK.";
     field {sw=rw; hw=r; swwel;resetsignal = cptra_rst_b;} PAUSER[32]=0xFFFF_FFFF;
 } CPTRA_MBOX_VALID_PAUSER[5];

//FIXME: Should LOCK be W1 here?
reg {
    name = "Valid User Register Lock";
     desc = "Valid PAUSER attributes for requests from SoC APB Interface.
             [br]Each bit corresponds to locking the associated MBOX_VALID_PAUSER register.
             [br]Associated MBOX_VALID_PAUSER register is only valid once locked by this bit.
             [br]Caliptra Access: RW
             [br]SOC Access:      RW
             [br]Read-Only once locked.";
     field {sw=rw; hw=r; swwel; resetsignal = cptra_rst_b;} LOCK=0;
 } CPTRA_MBOX_PAUSER_LOCK[5];

reg {
    name = "Valid User for TRNG";
    desc = "Valid PAUSER attributes for TRNG on SoC APB Interface. Only valid once LOCK is set.
            [br]Caliptra Access: RW
            [br]SOC Access:      RW
            [br]Read-Only once locked by TRNG_PAUSER_LOCK.";
    field {sw=rw; hw=r; swwel; resetsignal = cptra_rst_b;} PAUSER[32]=0xFFFF_FFFF;
 } CPTRA_TRNG_VALID_PAUSER;

reg {
    name = "Valid User for TRNG PAUSER Lock";
    desc = "Valid PAUSER attributes for requests from SoC APB Interface.
            [br]Each bit corresponds to locking the associated TRNG_VALID_PAUSER register.
            [br]Associated TRNG_VALID_PAUSER register is only valid once locked by this bit.
            [br]Caliptra FW RW access for survivability but cannot unlock once locked
            [br]Caliptra Access: RW
            [br]SOC Access:      RW
            [br]Read-Only once locked.";
    field {sw=rw; hw=r; swwel; resetsignal=cptra_rst_b;} LOCK=0;
 } CPTRA_TRNG_PAUSER_LOCK;

reg {
    name = "TRNG Data";
    desc = "Storage for the requested TRNG Data.
            [br]Caliptra Access: RO
            [br]SOC Access:      RW";
    field {sw=rw; hw=na; swwe; swacc; hwclr; resetsignal=cptra_rst_b;} DATA[32]=0;
 } CPTRA_TRNG_DATA[12];

 reg {
    name = "TRNG Ctrl";
    desc = "TRNG Control register to clear data registers";
    field {desc = "Indicates that TRNG Data can be cleared
            [br]Caliptra Access: RW
            [br]SOC Access:      RO";  sw=rw; hw=r; singlepulse; swwel=soc_req; resetsignal=cptra_rst_b;} clear=0;
} CPTRA_TRNG_CTRL;

reg {
    name = "TRNG Status";
    desc = "TRNG Status register to indicate request and done";
    field {desc = "Indicates that there is a request for TRNG Data.
            [br]Caliptra Access: RW
            [br]SOC Access:      RO";  sw=rw; hw=r; swwel=soc_req; resetsignal=cptra_rst_b;} DATA_REQ=0;

    field {desc = "Indicates that the requests TRNG Data is done and stored in the TRNG Data register.
            [br]Caliptra Access: RO
            [br]SOC Access:      RW
            [br]When DATA_REQ is 0 DATA_WR_DONE will also be 0";  sw=rw; hw=na; swwe; hwclr; resetsignal=cptra_rst_b;} DATA_WR_DONE=0;
 } CPTRA_TRNG_STATUS;

reg {
    name = "Fuse Write Done";
    desc = "Writes to fuse registers are completed. After the done bit is set, any subsequent writes to a fuse register will be dropped unless there is a power cycle or a warm reset or caliptra FW allows a write (negotiated through a mailbox command).
             [br]Caliptra Access: RO
             [br]SOC Access:      RW1-S";
     field {sw=rw; hw=r; swmod=true; swwe; resetsignal=cptra_pwrgood;} done[1]=0;
} CPTRA_FUSE_WR_DONE;

reg {
    name = "Timer Config";
    desc = "Provides the clock period of the system clock.
            Used to standardize the RISC-V Standard MTIME count register.
            Clock Period is indicated as an integer number of picoseconds.
            [br]Caliptra Access: RW
            [br]SOC Access:      RW";
    field {desc = "Period in (ps)"; sw=rw; hw=na; resetsignal = cptra_pwrgood;} clk_period[32] = 32'h0;
} CPTRA_TIMER_CONFIG;

reg {
    name = "BOOTFSM GO";
    desc = "Indicates that the BootFSM can continue to execute to bring the uController out of reset
            [br]Caliptra Access: RO
            [br]SOC Access:      RW
            [br]TAP Access [in debug/manuf mode]: RW";
    field {sw=rw; hw=rw; we=true; swwe=soc_req; resetsignal = cptra_rst_b;} GO[1]=0;
} CPTRA_BOOTFSM_GO;

reg {
    name = "DEBUG & MANUF SERVICE REG";
    desc = "JTAG in debug/manuf mode or SOC can write to this register for ROM/FW defined skips or services; ROM/FW maintains the defintion of these bits.
            [br]Field decode:
            [br] [0]     MFG_FLAG_GEN_IDEV_CSR: Enable bit for Caliptra to generate an IDEV CSR
            [br] [15:1]  MFG_FLAG_RSVD
            [br] [30:16] FAKE_ROM_RSVD
            [br] [31]    FAKE_ROM_IMAGE_VERIFY_EN: Enable bit to perform image verification within the fake-rom feature
            [br]
            [br]Caliptra Access: RW
            [br]SOC Access:      RW
            [br]TAP Access [in debug/manuf mode]: RW";
    field {sw=rw; hw=rw; we=true;resetsignal = cptra_rst_b;} DATA[32] = 32'h0;
} CPTRA_DBG_MANUF_SERVICE_REG;

reg {
    name = "Global Caliptra Clk gating enable";
    desc = "Control register to enable or disable all of the caliptra clk gating. Default is 0 (disabled).
            [br]Caliptra Access: RO
            [br]SOC Access:      RW";
    field {desc = "Clk gating enable"; hw = r; sw = rw; swwe = soc_req; resetsignal = cptra_rst_b;} clk_gating_en = 1'b0;
} CPTRA_CLK_GATING_EN;

reg {
    name = "Generic Input Wires";
    desc = "Generic input wires connected to SoC interface.
            [br]Caliptra Access: RO
            [br]SOC Access:      RO";
    field {sw=r; hw=rw; resetsignal = cptra_rst_b;} generic_wires[32]=0;
} CPTRA_GENERIC_INPUT_WIRES[2];
reg {
    name = "Generic Output Wires";
    desc = "Generic output wires connected to SoC interface.
            [br]Caliptra Access: RW
            [br]SOC Access:      RO";
    field {sw=rw; hw=r; swwel = soc_req; resetsignal = cptra_rst_b;} generic_wires[32]=0;
} CPTRA_GENERIC_OUTPUT_WIRES[2];
reg {
    name = "Caliptra HW RevID";
    desc = "Caliptra HW revision ID that matches the official final release milestone
            SoC stepping ID is repopulated with the value in the fuse register on every warm reset
            [br]Caliptra Access: RO
            [br]SOC Access:      RO";
    field {sw=r; resetsignal = cptra_rst_b;} CPTRA_GENERATION[16]=1;
    field {sw=r; hw=w; resetsignal = cptra_rst_b;} SOC_STEPPING_ID[16]=0;
} CPTRA_HW_REV_ID;
reg {
    name = "Caliptra FW RevID";
    desc = "Caliptra FW revision ID
            [br]Caliptra Access: RW
            [br]SOC Access:      RO";
    field {sw=rw; hw=r; swwel = soc_req; resetsignal = cptra_rst_b;} REV_ID[32]=0;
} CPTRA_FW_REV_ID[2];
reg {
    name = "Caliptra HW Config";
    desc = "Caliptra HW Configuration
            [br]Caliptra Access: RO
            [br]SOC Access:      RO";
    // No storage, i.e. no resetsignal
    field {sw=r; hw=w;} iTRNG_en;
    field {sw=r; hw=w;} QSPI_en;
    field {sw=r; hw=w;} I3C_en;
    field {sw=r; hw=w;} UART_en;
} CPTRA_HW_CONFIG;

//Timer1
reg {
    name = "Caliptra WDT Timer1 EN register";
    desc = "Caliptra watchdog timer1 enable register
            [br]Caliptra Access: RW
            [br]SOC Access:      RO";
    field {desc = "WDT timer1 enable"; hw = r; sw = rw; swwel = soc_req; resetsignal = cptra_rst_b;} timer1_en = 1'b0;
} CPTRA_WDT_TIMER1_EN;

reg {
    name = "Caliptra WDT Timer1 CTRL register";
    desc = "Caliptra watchdog timer1 control register
            [br]Caliptra Access: RW
            [br]SOC Access:      RO";
    field {desc = "WDT timer1 restart"; hw = r; sw = rw; swwel = soc_req; resetsignal = cptra_rst_b; singlepulse;} timer1_restart = 1'b0;
} CPTRA_WDT_TIMER1_CTRL;

reg {
    name = "Caliptra WDT Timer1 Timeout Period register";
    desc = "Caliptra watchdog timer1 timeout register
            [br]Caliptra Access: RW
            [br]SOC Access:      RO";
    field {desc = "WDT timer1 timeout period"; hw = r; sw = rw; swwel = soc_req; resetsignal = cptra_rst_b;} timer1_timeout_period[32] = 32'hFFFFFFFF;
} CPTRA_WDT_TIMER1_TIMEOUT_PERIOD[2]; //This reflects WDT_TIMEOUT_PERIOD_NUM_DWORDS in soc_ifc_pkg

//Timer2
reg {
    name = "Caliptra WDT Timer2 EN register";
    desc = "Caliptra watchdog timer2 enable register. Note: Setting this to 1 will disable the default cascaded mode and will have both timers count independently.
            [br]Caliptra Access: RW
            [br]SOC Access:      RO
            ";
    field {desc = "WDT timer2 enable"; hw = r; sw = rw; swwel = soc_req; resetsignal = cptra_rst_b;} timer2_en = 1'b0;
} CPTRA_WDT_TIMER2_EN;

reg {
    name = "Caliptra WDT Timer2 CTRL register";
    desc = "Caliptra watchdog timer2 control register
            [br]Caliptra Access: RW
            [br]SOC Access:      RO";
    field {desc = "WDT timer2 restart"; hw = r; sw = rw; swwel = soc_req; resetsignal = cptra_rst_b; singlepulse;} timer2_restart = 1'b0;
} CPTRA_WDT_TIMER2_CTRL;

reg {
    name = "Caliptra WDT Timer2 Timeout Period register";
    desc = "Caliptra watchdog timer2 timeout register
            [br]Caliptra Access: RW
            [br]SOC Access:      RO";
    field {desc = "WDT timer2 timeout period"; hw = r; sw = rw; swwel = soc_req; resetsignal = cptra_rst_b;} timer2_timeout_period[32] = 32'hFFFFFFFF;
} CPTRA_WDT_TIMER2_TIMEOUT_PERIOD[2]; //This reflects WDT_TIMEOUT_PERIOD_NUM_DWORDS in soc_ifc_pkg

//Status
reg {
    name = "Caliptra WDT STATUS register";
    desc = "Caliptra watchdog timer status register
            [br]Caliptra Access: RW
            [br]SOC Access:      RO";
    field {desc = "Timer1 timed out, timer2 enabled"; hw = rw; sw = rw; swwel = soc_req; resetsignal = cptra_rst_b;} t1_timeout = 1'b0;
    field {desc = "Timer2 timed out"; hw = rw; sw = rw; swwel = soc_req; resetsignal = cptra_rst_b;} t2_timeout = 1'b0;
} CPTRA_WDT_STATUS;

reg {
    name = "Valid User for FUSE";
    desc = "Valid PAUSER attributes for FUSE on SoC APB Interface. Only valid once LOCK is set.
            [br]Caliptra Access: RW
            [br]SOC Access:      RW
            [br]Read-Only once locked by FUSE_PAUSER_LOCK.";
    field {sw=rw; hw=r; swwel; resetsignal = cptra_pwrgood;} PAUSER[32]=0xFFFF_FFFF;
 } CPTRA_FUSE_VALID_PAUSER;

reg {
    name = "Valid User for FUSE PAUSER Lock";
    desc = "Valid PAUSER attributes for requests from SoC APB Interface.
            [br]Each bit corresponds to locking the associated FUSE_VALID_PAUSER register.
            [br]Associated FUSE_VALID_PAUSER register is only valid once locked by this bit.
            [br]Caliptra FW RW access for survivability but cannot unlock once locked
            [br]Caliptra Access: RW
            [br]SOC Access:      RW
            [br]Read-Only once locked.";
    field {sw=rw; hw=r; swwel; resetsignal=cptra_pwrgood;} LOCK=0;
 } CPTRA_FUSE_PAUSER_LOCK;

reg {
    name = "Caliptra WDT1 Config";
    desc = "SOC provided count in cycles for WDT1 timeout.";
    field {sw=rw; hw=na; resetsignal = cptra_pwrgood;} TIMEOUT[32]=0;
 } CPTRA_WDT_CFG[2];

reg {
    name = "Caliptra iTRNG Entropy Configuration 0";
    desc = "Adaptive threshold values for entropy source health tests.";
    field {sw=rw; resetsignal=cptra_rst_b;} low_threshold[16]=0;
    field {sw=rw; resetsignal=cptra_rst_b;} high_threshold[16]=0;
 } CPTRA_iTRNG_ENTROPY_CONFIG_0;

reg {
    name = "Caliptra iTRNG Entropy Configuration 1";
    desc = "Repetition count value for entropy source health tests.";
    field {sw=rw; resetsignal=cptra_rst_b;} repetition_count[16]=0;
    field {sw=rw; resetsignal=cptra_rst_b;} RSVD[16]=0;
 } CPTRA_iTRNG_ENTROPY_CONFIG_1;

reg {
    name = "Caliptra Reserved Registers";
    desc = "Set of reserved registers for survivability";
    field {sw=rw; resetsignal=cptra_rst_b;} RSVD[32]=0;
 } CPTRA_RSVD_REG[2];
