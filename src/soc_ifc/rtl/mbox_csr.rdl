// SPDX-License-Identifier: Apache-2.0
//
// Licensed under the Apache License, Version 2.0 (the "License");
// you may not use this file except in compliance with the License.
// You may obtain a copy of the License at
//
// http://www.apache.org/licenses/LICENSE-2.0
//
// Unless required by applicable law or agreed to in writing, software
// distributed under the License is distributed on an "AS IS" BASIS,
// WITHOUT WARRANTIES OR CONDITIONS OF ANY KIND, either express or implied.
// See the License for the specific language governing permissions and
// limitations under the License.
//


addrmap mbox_csr {
    desc="address maps for mbox register space";
    littleendian = true;
    default hw = na;
    signal {activelow; async; cpuif_reset; field_reset;} reset_b;
    signal {activelow; async;} hard_reset_b;

    signal {} lock_set;
    signal {} valid_user;

    //signal to indicate request is coming from soc side
    signal {} soc_req;

    //defined fields by access type
    //first is uc access type, second is soc access type
    field rw_ro {swwel = soc_req;}; //writes enabled only for uc
    field ro_rw {swwe  = soc_req;}; //writes enabled only for soc
    field ro_ro {sw = r;};
    field rw_rw {};

    // lock register
    // set on read, indicate to mailbox when modified
    // clear comes from mailbox control
    reg {
        name="Mailbox Lock";
        desc="Mailbox lock register for mailbox access, reading 0 will set the lock";
        field {rset; sw=r; hw=r; hwclr=true; swmod=true;} lock=0;
    } mbox_lock;

    // user register
    // store user from interface when setting lock
    reg {
        name="Mailbox User";
        desc="Stores the user that locked the mailbox";
        field {sw=r; hw=rw; we=lock_set;} user[32]=0;
    } mbox_user;

    reg {
        name="Mailbox Command";
        desc="Command requested for data in mailbox";
        field {sw=rw; hw=na; swwe=valid_user; swmod=true;} command[32]=0;
    } mbox_cmd;

    reg {
        name="Mailbox Data Length";
        desc="Data length for mailbox access";
        field {sw=rw; hw=na; swwe=valid_user; swmod=true;} length[32]=0;
    } mbox_dlen;

    reg {
        name="Mailbox DataIn";
        desc="Data in register, write the next data to mailbox";
        field {sw=rw; hw=na; swwe=valid_user; swmod=true;} datain[32];
    } mbox_datain;

    reg {
        name="Mailbox DataOut";
        desc="Data out register, read the next data from mailbox";
        field {sw=rw; hw=w; we; swwe; swacc=true;} dataout[32];
    } mbox_dataout;

    reg {
        name="Mailbox Execute";
        desc="Mailbox execute register indicates to receiver that the sender is done";
        field {sw=rw; hw=r;} execute=0;
    } mbox_execute;

    reg {
        name="Mailbox Status";
        desc="Status of the mailbox command";
        field {
            name = "Mailbox Status";
            desc = "Indicates the status of mailbox command";

            enum mbox_status_e {
                CMD_BUSY = 2'd0 {
                    desc = "Receiver is busy, command is not yet complete.";
                };
                DATA_READY = 2'd1 {
                    desc = "Requested data is ready in the mailbox.";
                };
                CMD_COMPLETE = 2'd2 {
                    desc = "Requested command is complete.";
                };
                CMD_FAILURE = 2'd3 {
                    desc = "The requested command experienced a failure.";
                };
            };
            sw=rw; hw=na; encode = mbox_status_e;} status[2]=0;
    } mbox_status;

};
