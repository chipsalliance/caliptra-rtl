// SPDX-License-Identifier: Apache-2.0
//
// Licensed under the Apache License, Version 2.0 (the "License");
// you may not use this file except in compliance with the License.
// You may obtain a copy of the License at
//
// http://www.apache.org/licenses/LICENSE-2.0
//
// Unless required by applicable law or agreed to in writing, software
// distributed under the License is distributed on an "AS IS" BASIS,
// WITHOUT WARRANTIES OR CONDITIONS OF ANY KIND, either express or implied.
// See the License for the specific language governing permissions and
// limitations under the License.
//


addrmap mbox_csr {
    desc="address maps for mbox register space";
    littleendian = true;
    default hw = na;
    signal {activelow; async; cpuif_reset; field_reset;} cptra_rst_b;
    signal {activelow; async;} cptra_pwrgood;
    default resetsignal=cptra_rst_b;
    
    //signal to indicate request is coming from soc side
    signal {} soc_req;
    signal {} lock_set;
    signal {} valid_requester;
    signal {} valid_receiver;

    // lock register
    // set on read, indicate to mailbox when modified
    // clear comes from mailbox control
    reg {
        name="Mailbox Lock";
        desc="Mailbox lock register for mailbox access, reading 0 will set the lock
        [br]Caliptra Access: RO
        [br]SOC Access:      RO";
        field {rset; sw=r; hw=r; hwclr=true; swmod=true;} lock=0;
    } mbox_lock;

    // user register
    // store user from interface when setting lock
    reg {
        name="Mailbox User";
        desc="Stores the user that locked the mailbox
        [br]Caliptra Access: RO
        [br]SOC Access:      RO";
        field {sw=r; hw=rw; we=lock_set;} user[32]=0;
    } mbox_user;

    reg {
        name="Mailbox Command";
        desc="Command requested for data in mailbox
        [br]Caliptra Access: RW
        [br]SOC Access:      RW";
        field {sw=rw; hw=na; swwe=valid_requester; swmod=true;} command[32]=0;
    } mbox_cmd;

    reg {
        name="Mailbox Data Length";
        desc="Data length for mailbox access in bytes
        [br]Caliptra Access: RW
        [br]SOC Access:      RW
        [br]TAP Access [in debug/manuf mode]: RO";
        field {sw=rw; hw=r; swwe=valid_requester; swmod=true;} length[32]=0;
    } mbox_dlen;

    reg {
        name="Mailbox DataIn";
        desc="Data in register, write the next data to mailbox
        [br]Caliptra Access: RW
        [br]SOC Access:      RW";
        field {sw=rw; hw=na; swwe=valid_requester; swmod=true;} datain[32]=0;
    } mbox_datain;

    reg {
        name="Mailbox DataOut";
        desc="Data out register, read the next data from mailbox
        [br]Caliptra Access: RO
        [br]SOC Access:      RO
        [br]TAP Access [in debug/manuf mode]: RO";
        field {sw=rw; hw=rw; we; swwe; swacc=true;} dataout[32]=0;
    } mbox_dataout;

    reg {
        name="Mailbox Execute";
        desc="Mailbox execute register indicates to receiver that the sender is done
        [br]Caliptra Access: RW
        [br]SOC Access:      RW";
        field {sw=rw; hw=r; swwe=valid_requester;} execute=0;
    } mbox_execute;

    reg {
        name="Mailbox Status";
        desc="Status of the mailbox command";
        field {
            name = "Mailbox Status";
            desc = "Indicates the status of mailbox command
                    [br]Caliptra Access: RW
                    [br]SOC Access:      RW
                    [br]TAP Access [in debug/manuf mode]: RO";

            enum mbox_status_e {
                CMD_BUSY = 4'd0 {
                    desc = "Receiver is busy, command is not yet complete.";
                };
                DATA_READY = 4'd1 {
                    desc = "Requested data is ready in the mailbox.";
                };
                CMD_COMPLETE = 4'd2 {
                    desc = "Requested command is complete.";
                };
                CMD_FAILURE = 4'd3 {
                    desc = "The requested command experienced a failure.";
                };
            };
            sw=rw; hw=r; swwe=valid_receiver; encode = mbox_status_e; hwclr;} status[4]=0;
        field {
            name = "Mailbox ECC Single Error";
            desc = "Indicates a correctable ECC single-bit error was
                    detected and corrected while reading dataout.
                    Auto-clears when mbox_execute field is cleared.
                    [br]Caliptra Access: RO
                    [br]SOC Access:      RO
                    [br]TAP Access [in debug/manuf mode]: RO";

            sw=r; hwset = true; hw=rw; wel; } ecc_single_error=1'b0;
        field {
            name = "Mailbox ECC Double Error";
            desc = "Indicates an uncorrectable ECC double-bit error
                    was detected while reading dataout.
                    Firmware developers are advised to set the command
                    status to CMD_FAILURE in response.
                    Auto-clears when mbox_execute field is cleared.
                    [br]Caliptra Access: RO
                    [br]SOC Access:      RO
                    [br]TAP Access [in debug/manuf mode]: RO";

            sw=r; hwset = true; hw=rw; wel; } ecc_double_error=1'b0;
        field {
            name = "Mailbox FSM Present State";
            desc = "Indicates the present state of the mailbox FSM
                    [br]Caliptra Access: RO
                    [br]SOC Access:      RO
                    [br]TAP Access [in debug/manuf mode]: RO";

            enum mbox_fsm_e {
                MBOX_IDLE = 3'b000 {
                    desc = "Mailbox is idle";
                };
                MBOX_RDY_FOR_CMD = 3'b001 {
                    desc = "Mailbox is waiting for command";
                };
                MBOX_RDY_FOR_DLEN = 3'b011 {
                    desc = "Mailbox is waiting for data length";
                };
                MBOX_RDY_FOR_DATA = 3'b010 {
                    desc = "Mailbox is ready for data";
                };
                MBOX_EXECUTE_UC = 3'b110 {
                    desc = "Mailbox has data for uC";
                };
                MBOX_EXECUTE_SOC = 3'b100 {
                    desc = "Mailbox has data for SoC";
                };
            };
            sw=r; hw=rw; encode = mbox_fsm_e;
        } mbox_fsm_ps[3] = 0;
        field {
            name = "SoC Acquired the Lock";
            desc = "Indicates that the current lock was acquired by the SoC
                    [br]Caliptra Access: RO
                    [br]SOC Access:      RO
                    [br]TAP Access [in debug/manuf mode]: RO";
            sw=r; hw=rw;} soc_has_lock=1'b0;
    } mbox_status;

    reg {
        name="Mailbox Force Unlock";
        desc="Capability for uC only to force unlock the mailbox.
              [br]Caliptra Access: RW
              [br]SOC Access:      RO";
        field {sw=rw; hw=r; singlepulse; swwel = soc_req;} unlock=0;
    } mbox_unlock;

    // This will auto clear the status register whenever a mailbox transfer
    // is not in progress. 1-cycle delayed from when the Receiver clears
    // the execute field.
    // For errors during AHB (direct-mode) reads, interrupt signals
    // will be used.
    mbox_status.ecc_single_error->wel  = mbox_execute.execute;
    mbox_status.ecc_double_error->wel  = mbox_execute.execute;
    mbox_status.ecc_single_error->next = mbox_execute.execute;
    mbox_status.ecc_double_error->next = mbox_execute.execute;

};
