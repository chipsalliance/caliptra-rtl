// SPDX-License-Identifier: Apache-2.0
//
// Licensed under the Apache License, Version 2.0 (the "License");
// you may not use this file except in compliance with the License.
// You may obtain a copy of the License at
//
// http://www.apache.org/licenses/LICENSE-2.0
//
// Unless required by applicable law or agreed to in writing, software
// distributed under the License is distributed on an "AS IS" BASIS,
// WITHOUT WARRANTIES OR CONDITIONS OF ANY KIND, either express or implied.
// See the License for the specific language governing permissions and
// limitations under the License.
//


reg {
    name="SHA Accelerator Lock";
    desc="SHA lock register for SHA access, reading 0 will set the lock, Write 1 to clear the lock
          [br]Caliptra Access: RW
          [br]SOC Access:      RW";
    field {rset; woclr; sw=rw; hw=r; swwe=valid_user; swmod=true;} LOCK=0;
} LOCK;

reg {
    name="SHA Accelerator User";
    desc="Stores the user that locked the SHA
          [br]Caliptra Access: RO
          [br]SOC Access:      RO";
    field {sw=r; hw=rw; we=lock_set;} USER[32]=0;
} USER;

reg {
    name="SHA Accelerator Mode";
    desc="Stores the requested mode for the SHA to execute.
          SHA Supports both SHA384 and SHA512 modes of operation.
          SHA Supports streaming mode - SHA is computed on a stream of incoming data to datain register.
                       mailbox mode - SHA is computed on LENGTH bytes of data stored in the mailbox from START_ADDRESS.
          [br]Caliptra Access: RW
          [br]SOC Access:      RW";
    field {
        enum sha_cmd_e {
            SHA_STREAM_384 = 2'd0 {
                desc = "SHA is in SHA384, streaming mode";
            };
            SHA_STREAM_512 = 2'd1 {
                desc = "SHA is in SHA512, streaming mode";
            };
            SHA_MBOX_384 = 2'd2 {
                desc = "SHA is in SHA384, mailbox mode";
            };
            SHA_MBOX_512 = 2'd3 {
                desc = "SHA is in SHA512, mailbox mode";
            };
        };
        sw=rw; hw=r; swwe=valid_user; swmod=true; encode = sha_cmd_e;} MODE[2]=0;
    field {
        name="Endianness Toggle for SHA in mailbox mode";
        desc="Default behavior assumes that data in mailbox is little endian,
              When set to 0, data from mailbox will be swizzled from little to big endian at the byte level.
              When set to 1, data from the mailbox will be loaded into SHA as-is.
              [br]Caliptra Access: RW
              [br]SOC Access:      RW";
        sw=rw; hw=r; swwe=valid_user;} ENDIAN_TOGGLE=0;
} MODE;

reg {
    name="SHA Accelerator Data Start Address";
    desc="The start address for FW controlled SHA performed on data stored in the mailbox.
          Start Address must be dword aligned.
          [br]Caliptra Access: RW
          [br]SOC Access:      RW";
    field {sw=rw; hw=r; swwe=valid_user;} ADDR[32]=0;
} START_ADDRESS;

reg {
    name="SHA Accelerator Data Length";
    desc="The length of data to be processed in bytes.
          [br]Caliptra Access: RW
          [br]SOC Access:      RW";
    field {sw=rw; hw=r; swwe=valid_user;} LENGTH[32]=0;
} DLEN;

reg {
    name="SHA Accelerator Data In";
    desc="Data in register for SHA Streaming function
          [br]Caliptra Access: RW
          [br]SOC Access:      RW";
    field {sw=rw; hw=na; swwe=valid_user; swmod=true;} DATAIN[32]=0;
} DATAIN;

reg {
    name="SHA Accelerator Execute";
    desc="For Streaming Function, indicates that the initiator is done streaming.
          For the Mailbox SHA Function, indicates that the SHA can begin execution.
          [br]Caliptra Access: RW
          [br]SOC Access:      RW";
    field {sw=rw; hw=r; hwclr; swwe=valid_user;} EXECUTE=0;
} EXECUTE;

reg {
    name = "SHA Accelerator Status";
    desc = "Status register indicating when the requested function is complete
            [br]Caliptra Access: RO
            [br]SOC Access:      RO";

    default sw = r;
    default hw = rw;
    default resetsignal = cptra_rst_b;
    field {desc = "Valid bit, indicating that the digest is complete";} VALID = 1'b0;
    field {name = "SoC Acquired the Lock";
           desc = "Indicates that the current lock was acquired by the SoC";} SOC_HAS_LOCK=1'b0;

} STATUS;

reg {
    name = "SHA Accelerator Digest";
    desc = "16 32-bit registers storing the 512-bit digest output in
            big-endian representation.
            [br]Caliptra Access: RO
            [br]SOC Access:      RO";

    default sw = r;
    default hw = w;
    default resetsignal = cptra_rst_b;
    field {desc = "Output digest field"; hwclr;} DIGEST[32] = 32'b0;

} DIGEST[16];

reg {
    name = "SHA Accelerator Control";
    desc = "SHA Accelerator control flows. 
            [br]Zeroize the SHA engine internal registers.
            [br]Caliptra Access: RW
            [br]SOC Access:      RW";
        field {desc = "Zeroize all internal registers"; sw=rw; hw=r; singlepulse;} ZEROIZE = 1'b0;
} CONTROL;
