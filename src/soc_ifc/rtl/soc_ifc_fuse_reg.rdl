// SPDX-License-Identifier: Apache-2.0
//
// Licensed under the Apache License, Version 2.0 (the "License");
// you may not use this file except in compliance with the License.
// You may obtain a copy of the License at
//
// http://www.apache.org/licenses/LICENSE-2.0
//
// Unless required by applicable law or agreed to in writing, software
// distributed under the License is distributed on an "AS IS" BASIS,
// WITHOUT WARRANTIES OR CONDITIONS OF ANY KIND, either express or implied.
// See the License for the specific language governing permissions and
// limitations under the License.
//
////////////////////////////////////////////////////////////////
// FUSE Registers
// All fuses persist across caliptra reset. Locked by Fuse WR done. "Read/Write Lock - Sticky" => RWL-S

field secret {sw = w1; hw = r; swwel; hwclr; resetsignal = cptra_pwrgood;};
field key    {sw = w; swwe; hw = rw; wel; hwclr;};
field Fuse   {sw = rw; hw = r; swwel; resetsignal = cptra_pwrgood;};

reg {
    name = "Unique Device Secret";
    desc = "Obfuscated UDS.
            [br]Caliptra Access: -
            [br]SOC Access:      WL-S";
    secret seed[32]=0;
} fuse_uds_seed[12] @0x200;
reg {
    name = "Field Entropy";
    desc = "Obfuscated Field Entropy.
            [br]Caliptra Access: -
            [br]SOC Access:      WL-S";
    secret seed[32]=0;
} fuse_field_entropy[8];
reg {
    desc = "Key Manifest PK hash Fuse.
             [br]Caliptra Access: RO
             [br]SOC Access:      RWL-S";
    Fuse hash[32]=0;
} fuse_key_manifest_pk_hash[12];
reg {
    desc = "Key Manifest Mask Fuse.
             [br]Caliptra Access: RO
             [br]SOC Access:      RWL-S";
     Fuse mask[4]=0;
} fuse_key_manifest_pk_hash_mask;
reg {
    desc = "Owner PK hash Fuse.
             [br]Caliptra Access: RO
             [br]SOC Access:      RWL-S";
    Fuse hash[32]=0;
} fuse_owner_pk_hash[12];
reg {
    desc = "FMC Security Version Number.
             [br]Caliptra Access: RO
             [br]SOC Access:      RWL-S";
    Fuse svn[32]=0;
} fuse_fmc_key_manifest_svn;
reg {
    desc = "Runtime SVN Fuse.
             [br]Caliptra Access: RO
             [br]SOC Access:      RWL-S";
    Fuse svn[32]=0;
} fuse_runtime_svn[4];
reg {
    desc = "Anti Rollback Disable Fuse.
             [br]Caliptra Access: RO
             [br]SOC Access:      RWL-S";
    Fuse dis[1]=0;
} fuse_anti_rollback_disable;
reg {
    desc = "Manufacturer IEEE IDevID Certificate Gen Attributes.
             [br]Caliptra Access: RO
             [br]SOC Access:      RWL-S";
    Fuse cert[32]=0;
} fuse_idevid_cert_attr[24];
reg {
    desc = " Manufacturer IDEVID Manufacturer’s HSM identifier (this is used to find the certificate chain from the boot media)
             [br]Caliptra Access: RO
             [br]SOC Access:      RWL-S";
    Fuse hsm_id[32]=0;
} fuse_idevid_manuf_hsm_id[4];
reg {
    desc = " Caliptra Boot Media Integrated mode usage only. SOCs that build with a Boot Media Independent profile don’t have to account for these fuses.
             [br]Caliptra Access: RO
             [br]SOC Access:      RWL-S";
    Fuse life_cycle[2]=0;
} fuse_life_cycle;
reg {
    desc = "0 - Verify Caliptra firmware images with ECDSA-only; 1 - Verify Caliptra firmware images with both ECDSA and LMS 
             [br]Caliptra Access: RO
             [br]SOC Access:      RWL-S";
    Fuse lms_verify[1]=0;
} fuse_lms_verify;
reg {
    desc = "Bits for revoking LMS public keys in the key manifest
             [br]Caliptra Access: RO
             [br]SOC Access:      RWL-S";
    Fuse lms_revocation[32]=0;
} fuse_lms_revocation;


