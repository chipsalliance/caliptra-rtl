// SPDX-License-Identifier: Apache-2.0
//
// Licensed under the Apache License, Version 2.0 (the "License");
// you may not use this file except in compliance with the License.
// You may obtain a copy of the License at
//
// http://www.apache.org/licenses/LICENSE-2.0
//
// Unless required by applicable law or agreed to in writing, software
// distributed under the License is distributed on an "AS IS" BASIS,
// WITHOUT WARRANTIES OR CONDITIONS OF ANY KIND, either express or implied.
// See the License for the specific language governing permissions and
// limitations under the License.
//


addrmap ecc_reg {
    desc="address maps for ecc register space";
    default hw = na;
    signal {activelow; async; cpuif_reset; field_reset;} reset_b;
    signal {activelow; async;} hard_reset_b;

    //signal to indicate request is coming from soc side
    signal {} soc_req;

    //defined fields by access type
    //first is uc access type, second is soc access type
    field rw_ro {swwel = soc_req;}; //writes enabled only for uc
    field ro_rw {swwe  = soc_req;}; //writes enabled only for soc
    field ro_ro {sw = r;};
    field rw_rw {};

    //defined fields by access type
    field sr_hw {sw = r; hw = w;};
    field srw_hr {sw = rw; hw = r;};
    field sr_hrw {sw = r; hw = rw;};
    field srw_hrw {sw = rw; hw = rw;};
    field sna_hrw {sw = w; hw = rw;};

    reg {sr_hw NAME[32];} ecc_NAME[2];
    reg {sr_hw VERSION[32];} ecc_VERSION[2];

    reg {srw_hrw CTRL[2];} ecc_CTRL @0x00000010;
    reg {sr_hw STATUS[2];} ecc_STATUS @0x00000018;
    reg {srw_hrw SCACONFIG[3];} ecc_SCACONFIG @0x00000020;
    
    reg {srw_hrw SEED[32];} ecc_SEED[12] @0x00000080;
    reg {srw_hr MSG[32];} ecc_MSG[12] @0x00000100;

    reg {srw_hrw PRIVKEY[32];} ecc_PRIVKEY[12] @0x00000180;
    reg {srw_hrw PUBKEY_X[32];} ecc_PUBKEY_X[12] @0x00000200;
    reg {srw_hrw PUBKEY_Y[32];} ecc_PUBKEY_Y[12] @0x00000280;
    
    reg {srw_hrw R[32];} ecc_R[12] @0x00000300;
    reg {srw_hrw S[32];} ecc_S[12] @0x00000380;
    reg {sr_hrw VERIFY_R[32];} ecc_VERIFY_R[12] @0x00000400;
    
    reg {srw_hr IV[32];} ecc_IV[12] @0x00000480;
};
