// SPDX-License-Identifier: Apache-2.0
//
// Licensed under the Apache License, Version 2.0 (the "License");
// you may not use this file except in compliance with the License.
// You may obtain a copy of the License at
//
// http://www.apache.org/licenses/LICENSE-2.0
//
// Unless required by applicable law or agreed to in writing, software
// distributed under the License is distributed on an "AS IS" BASIS,
// WITHOUT WARRANTIES OR CONDITIONS OF ANY KIND, either express or implied.
// See the License for the specific language governing permissions and
// limitations under the License.
//




addrmap ecc_reg {
    desc="address maps for ecc register space";


    addressing = regalign; // This is the default if not specified
    lsb0 = true; // lsb0 property is implicit/default. See docs for
                 // SystemRDL 2.0 sections 9.1 and 13.4

    default hw = na;
    signal {activelow; async; cpuif_reset; field_reset;} reset_b;
    signal {activelow; async;} hard_reset_b;
    signal {} ecc_ready;


    /* -----------------------
    * Register definitive definitions
    * ----------------------- */

    /* ---- ECC Component Name ---- */
    reg {
        name = "ECC component name register type definition";
        desc = "Two 32-bit read-only registers repereseting of the name
                of ECC component. These registers are located at
                ECC_base_address + 0x0000_0000 and 0x0000_0004 addresses.";

        default sw = r;
        default hw = w;
        field {desc = "Name field";} NAME[32];

    } ECC_NAME[2] @0x00000000;



    /* ---- ECC Component Version ---- */
    reg {
        name = "ECC component version register type definition";
        desc = "Two 32-bit read-only registers repereseting of the version
                of ECC component. These registers are located at
                ECC_base_address + 0x0000_0008 and 0x0000_000C addresses.";

        default sw = r;
        default hw = w;
        field {desc = "Version field";} VERSION[32];
        
    } ECC_VERSION[2] @0x00000008;



    /* ---- ECC Component Control ---- */
    reg {
        name = "ECC component control register type definition";
        desc = "One 4-bit register to set the type of ECC operations.
                [br] bit #[1:0]: This can be: 
                [br]             00 for NONE
                [br]             01 for KEYGEN
                [br]             10 for SIGNING
                [br]             11 for VERIFYING
                [br] bit #2: Zeroize all internal registers after ECC process, to avoid SCA leakage.
                [br] bit #3: Run ECC Signing flow to sign PCRs.
                [br] This register is located at ECC_base_address + 0x0000_0010.";

        default sw = w;
        default hw = r;
        default resetsignal = reset_b;
        field {desc = "Control command field"; swwe = ecc_ready; hwclr;} CTRL[2] = 2'b0;
        field {desc = "Zeroize all internal registers"; swwe = ecc_ready; singlepulse;} ZEROIZE = 1'b0;
        field {desc = "Run PCR Signing flow"; swwe = ecc_ready; hwclr;} PCR_SIGN = 1'b0;
    
    } ECC_CTRL @0x00000010;



    /* ---- ECC Component Status ---- */
    reg {
        name = "ECC component status register type definition";
        desc = "One 2-bit register including the following flags: 
                bit #0: READY : ​Indicates if the core is ready to take
                                a control command and process the block.  
                bit #1: VALID : ​Indicates if the process is done and the
                                hash value stored in DIGEST registers is valid. 
                This register is located at ECC_base_address + 0x0000_0018.";

        default sw = r;
        default hw = w;
        default resetsignal = reset_b;
        field {desc = "Status ready bit";} READY = 1'b0;
        field {desc = "Status valid bit";} VALID = 1'b0;
    
    } ECC_STATUS @0x00000018;

    /* ---- ECC Component Side-Channel Countermeasure Configuration ---- */
    reg {
        name = "ECC component SCA configuration register type definition";
        desc = "One 3-bit register to enable/disable the ECC SCA countermeasures.
                bit #0: POINT_RND_EN : ​Indicates if the base point randomization 
                                       countermeasure is enabled.
                bit #1: MASK_SIGN_EN: ​Indicates if the mask countermeasure in SIGNING
                                      is enabled.
                bit #2: SCALAR_RND_EN: ​Indicates if the scalar ransomization countermeasure
                                      is enabled.
                                
                This register is located at ECC_base_address + 0x0000_0020.";

        default sw = w;
        default hw = r;
        default resetsignal = reset_b;
        field {desc = "SCA point randomization field"; swwe = ecc_ready;} POINT_RND_EN = 1'b1;
        field {desc = "SCA mask signing field"; swwe = ecc_ready;} MASK_SIGN_EN = 1'b1;
        field {desc = "SCA scalar randomization field"; swwe = ecc_ready;} SCALAR_RND_EN = 1'b1;
    
    } ECC_SCACONFIG @0x00000020;



    /* ---- ECC Component Input SEED ---- */
    reg {
        name = "ECC component seed register type definition";
        desc = "12 32-bit registers storing the 384-bit seed for keygen.
                The seed can be any 384-bit value in [0 : 2^384-1].
                These registers are located at ECC_base_address + 
                0x0000_0080 to 0x0000_00AC in big-endian representation.";

        default sw = w;
        default hw = rw;
        default we = true;
        default resetsignal = reset_b;
        field {desc = "Input seed field"; swwe = ecc_ready; hwclr;} SEED[32] = 32'b0;
    
    } ECC_SEED[12] @0x00000080;

    
    /* ---- ECC Component Input NONCE ---- */
    reg {
        name = "ECC component nonce register type definition";
        desc = "12 32-bit registers storing the 384-bit nonce for keygen.
                The nonce can be any 384-bit value in [0 : 2^384-1].
                These registers are located at ECC_base_address + 
                0x0000_0500 to 0x0000_052C in big-endian representation.";

        default sw = w;
        default hw = r;
        default resetsignal = reset_b;
        field {desc = "Input nonce field"; swwe = ecc_ready; hwclr;} NONCE[32] = 32'b0;
    
    } ECC_NONCE[12] @0x00000500;



    /* ---- ECC Component Input Message ---- */
    reg {
        name = "ECC component hashed message register type definition";
        desc = "12 32-bit registers storing the hash of the message respect 
                to SHA384 algorithm.
                The hashed message can be any 384-bit value in [0 : 2^384-1].
                These registers are located at ECC_base_address + 
                0x0000_0100 to 0x0000_012C in big-endian representation.";

        default sw = w;
        default hw = rw;
        default we = true;
        default resetsignal = reset_b;
        field {desc = "Input message field"; swwe = ecc_ready; hwclr;} MSG[32] = 32'b0;
    
    } ECC_MSG[12] @0x00000100;



    /* ---- ECC Component Private Key OUT---- */
    reg {
        name = "ECC component private key output register type definition";
        desc = "12 32-bit registers storing the private key for keygen.
                These registers is read by ECC user after keygen operation.
                The private key is in [1 : q-1] while q is the group
                order of the Secp384r1 curve.
                These registers are located at ECC_base_address + 
                0x0000_0180 to 0x0000_01AC in big-endian representation.";

        default sw = r;
        default hw = w;
        default we = true;
        default resetsignal = reset_b;
        field {desc = "Private key field"; hwclr;} PRIVKEY_OUT[32] = 32'b0;
    
    } ECC_PRIVKEY_OUT[12] @0x00000180;

    /* ---- ECC Component Private Key IN---- */
    reg {
        name = "ECC component private key input register type definition";
        desc = "12 32-bit registers storing the private key for signing. 
                These registers is set before signing operation.
                The private key should be in [1 : q-1] while q is the group
                order of the Secp384r1 curve.
                These registers are located at ECC_base_address + 
                0x0000_0580 to 0x0000_05AC in big-endian representation.";

        default sw = w;
        default hw = rw;
        default we = true;
        default resetsignal = reset_b;
        field {desc = "Private key field"; swwe = ecc_ready; hwclr;} PRIVKEY_IN[32] = 32'b0;
    
    } ECC_PRIVKEY_IN[12] @0x00000580;


    /* ---- ECC Component Public Key x ---- */
    reg {
        name = "ECC component public key (x) register type definition";
        desc = "12 32-bit registers storing the x coordinate of public key. 
                These registers is read by ECC user after keygen operation, 
                or be set before verifying operation.
                The public key x should be in [1 : p-1] while p is the prime
                number of the Secp384r1 curve.
                These registers are located at ECC_base_address + 
                0x0000_0200 to 0x0000_022C in big-endian representation.";

        default sw = rw;
        default hw = rw;
        default we = true;
        default resetsignal = reset_b;
        field {desc = "Public key x field"; swwe = ecc_ready; hwclr;} PUBKEY_X[32] = 32'b0;
    
    } ECC_PUBKEY_X[12] @0x00000200;


    /* ---- ECC Component Public Key y ---- */
    reg {
        name = "ECC component public key (y) register type definition";
        desc = "12 32-bit registers storing the y coordinate of public key. 
                These registers is read by ECC user after keygen operation, 
                or be set before verifying operation.
                The public key y should be in [1 : p-1] while p is the prime
                number of the Secp384r1 curve.
                These registers are located at ECC_base_address + 
                0x0000_0280 to 0x0000_02AC in big-endian representation.";

        default sw = rw;
        default hw = rw;
        default we = true;
        default resetsignal = reset_b;
        field {desc = "Public key y field"; swwe = ecc_ready; hwclr;} PUBKEY_Y[32] = 32'b0;
    
    } ECC_PUBKEY_Y[12] @0x00000280;

    

    /* ---- ECC Component Signature R ---- */
    reg {
        name = "ECC component signature R register type definition";
        desc = "12 32-bit registers storing the signature R of the message. 
                These registers is read by ECC user after signing operation, 
                or be set before verifying operation.
                The signature R should be in [1 : q-1] while q is the group
                order of the Secp384r1 curve.
                Based on RFC6979, If R turns out to be zero, a new nonce (by changing 
                the private key or the message) should be selected and R computed 
                again (this is an utterly improbable occurrence).
                These registers are located at ECC_base_address + 
                0x0000_0300 to 0x0000_032C in big-endian representation.";

        default sw = rw;
        default hw = rw;
        default we = true;
        default resetsignal = reset_b;
        field {desc = "Signature R field"; swwe = ecc_ready; hwclr;} SIGN_R[32] = 32'b0;
    
    } ECC_SIGN_R[12] @0x00000300;



    /* ---- ECC Component Signature S ---- */
    reg {
        name = "ECC component signature S register type definition";
        desc = "12 32-bit registers storing the signature S of the message. 
                These registers is read by ECC user after signing operation, 
                or be set before verifying operation.
                The signature S should be in [1 : q-1] while q is the group
                order of the Secp384r1 curve.
                These registers are located at ECC_base_address + 
                0x0000_0380 to 0x0000_03AC in big-endian representation.";

        default sw = rw;
        default hw = rw;
        default we = true;
        default resetsignal = reset_b;
        field {desc = "Signature S field"; swwe = ecc_ready; hwclr;} SIGN_S[32] = 32'b0;
    
    } ECC_SIGN_S[12] @0x00000380;
    
    


    /* ---- ECC Component Verify R Result ---- */
    reg {
        name = "ECC component verify R result register type definition";
        desc = "12 32-bit registers storing the result of verifying operation.
                Firmware is responsible for comparing the computed result with 
                the signature R, and if they are equal the signature is valid.
                The verify R result should be in [1 : q-1] while q is the group
                order of the Secp384r1 curve.
                These registers are located at ECC_base_address + 
                0x0000_0400 to 0x0000_042C in big-endian representation.";

        default sw = r;
        default hw = rw;
        default we = true;
        default resetsignal = reset_b;
        field {desc = "Output digest field"; hwclr;} VERIFY_R[32] = 32'b0;
    
    } ECC_VERIFY_R[12] @0x00000400;



    /* ---- ECC Component Input IV ---- */
    reg {
        name = "ECC component IV register type definition";
        desc = "12 32-bit registers storing the 384-bit IV required 
                for SCA countermeasures to randomize the inputs with no change
                on the ECC outputs. 
                The IV can be any 384-bit value in [0 : 2^384-1].
                These registers are located at ECC_base_address + 
                0x0000_0480 to 0x0000_04AC in big-endian representation.";

        default sw = w;
        default hw = r;
        default resetsignal = reset_b;
        field {desc = "Input IV field"; swwe = ecc_ready; hwclr;} IV[32] = 32'b0;
    
    } ECC_IV[12] @0x00000480;

    kv_read_ctrl_reg ecc_kv_rd_pkey_ctrl  @0x00000600;
    kv_status_reg ecc_kv_rd_pkey_status;
    kv_read_ctrl_reg ecc_kv_rd_seed_ctrl;
    kv_status_reg ecc_kv_rd_seed_status;
    kv_write_ctrl_reg ecc_kv_wr_pkey_ctrl;
    kv_status_reg ecc_kv_wr_pkey_status;

    ////////////////////////////////////////////////////////////////
    // Interrupts
    /* -----------------------
     * Register File definitive definition
     * ----------------------- */

    // Notifications are non-error events that occur during normal operation of the module.
    // E.g. a completion of a job may produce a notification.
    // Error and notification events are separated into separate status/trigger registers
    // to allow effective priority allocation by software
    regfile intr_block_t {


        /* -----------------------
         * Default properties for Register File
         * ----------------------- */

        name = "Interrupt Register Block";
        desc = "Set of registers to implement interrupt functionality
                for ECC";

        default regwidth = 32; // reg property
        default accesswidth = 32; // reg property
        default hw = na; // field property


        /* -----------------------
         * Register definitive definitions
         * ----------------------- */

        /* ---- Global Interrupt Enable ---- */
        reg global_intr_en_t {
            name = "Per-Type Interrupt Enable Register";
            desc = "Dedicated register with one bit for each event type that may produce an interrupt.";

            default hw = na;
            default sw = rw;

            // Global enablement (for interrupts of the event types defined for this module)
            field {desc = "Global enable bit for all events of type 'Error'";       } error_en = 1'b0;
            field {desc = "Global enable bit for all events of type 'Notification'";} notif_en = 1'b0;
        };

        /* ---- Error Interrupt Enable ---- */
        reg error_intr_en_t {
            name = "Per-Event Interrupt Enable Register";
            desc = "Dedicated register with one bit for each event that may produce an interrupt.";

            default hw = na;
            default sw = rw;

            // Specific enables for the events defined in this
            // event type in the instantiating peripheral.
            // TODO: Add en, sts, trig, cnt for all tracked errors
            field {desc = "Enable bit for Internal Errors";               } error_internal_en = 1'b0;
        };

        /* ---- Notification Interrupt Enable ---- */
        reg notif_intr_en_t {
            name = "Per-Event Interrupt Enable Register";
            desc = "Dedicated register with one bit for each event that may produce an interrupt.";

            default hw = na;
            default sw = rw;

            // Specific enables for the events defined in this
            // event type in the instantiating peripheral.
            field {desc = "Enable bit for Command Done";} notif_cmd_done_en = 1'b0;
        };

        /* ---- Error Interrupt Status ---- */
        reg error_intr_t {
            name = "Interrupt Status Register type definition";
            desc = "Single bit indicating occurrence of each interrupt event.
                    Sticky, level assertion, write-1-to-clear.";

            default precedence = hw;
            default hw = w;
            default hwset = true;
            default sw = rw;
            default woclr = true;
            default level intr;

            field {desc = "Internal Errors status bit";                 } error_internal_sts = 1'b0;
        };

        /* ---- Notification Interrupt Status ---- */
        reg notif_intr_t {
            name = "Interrupt Status Register type definition";
            desc = "Single bit indicating occurrence of each interrupt event.
                    Sticky, level assertion, write-1-to-clear.";

            default precedence = hw;
            default hw = w;
            default hwset = true;
            default sw = rw;
            default woclr = true;
            default level intr;

            field {desc = "Command Done status bit";} notif_cmd_done_sts = 1'b0;
        };

        /* ---- Aggregated Interrupt Status ---- */
        reg global_intr_t {
            name = "Interrupt Status Aggregation Register type definition";
            desc = "Single bit indicating occurrence of any interrupt event
                    of a given type. E.g. Notifications and Errors may drive
                    to two separate interrupt registers. There may be
                    multiple sources of Notifications or Errors that are
                    aggregated into a single interrupt pin for that
                    respective type. That pin feeds through this register
                    in order to apply a global enablement of that interrupt
                    event type.
                    Nonsticky assertion.";

            default hw = w;
            default sw = r;
            default nonsticky intr;

            field {desc = "Interrupt Event Aggregation status bit";} agg_sts = 1'b0;
        };

        /* ---- Error Interrupt Trigger ---- */
        reg error_intr_trig_t {
            name = "Interrupt Trigger Register type definition";
            desc = "Single bit for each interrupt event allows SW to manually
                    trigger occurrence of that event. Upon SW write, the bit
                    will pulse for 1 cycle then clear to 0.";

            default hw = na;
            default sw = rw;
            default woset = true;
            default singlepulse = true;

            // Instantiate triggers bit-by-bit.
            field {desc = "Internal Errors trigger bit";               } error_internal_trig = 1'b0;
        };

        /* ---- Notification Interrupt Trigger ---- */
        reg notif_intr_trig_t {
            name = "Interrupt Trigger Register type definition";
            desc = "Single bit for each interrupt event allows SW to manually
                    trigger occurrence of that event. Upon SW write, the bit
                    will pulse for 1 cycle then clear to 0.";

            default hw = na;
            default sw = rw;
            default woset = true;
            default singlepulse = true;

            // Instantiate triggers bit-by-bit.
            field {desc = "Command Done trigger bit";} notif_cmd_done_trig = 1'b0;
        };

        /* ---- Interrupt Statistics Counter Incrementor ---- */
        reg intr_count_incr_t {
            name = "Interrupt Event Count Incrementor";
            desc = "Trigger the event counter to increment based on observing
                    the rising edge of an interrupt event input from the
                    Hardware. The same input signal that causes an interrupt
                    event to be set (sticky) also causes this signal to pulse
                    for 1 clock cycle, resulting in the event counter
                    incrementing by 1 for every interrupt event.
                    This is implemented as a down-counter (1-bit) that will
                    decrement immediately on being set - resulting in a pulse";

            default hw = w;
            default sw = r; // Has to have some access.... ideally SW wouldn't even see this
            default hwset = true;
            default decrvalue = 1;
            default counter;

            field {desc = "Pulse mirrors interrupt event occurrence";} pulse = 1'b0;
        };

        /* ---- Interrupt Statistics Counter ---- */
        reg intr_count_t {
            name = "Interrupt Event Counter";
            desc = "Provides statistics about the number of events that have
                    occurred.
                    Will not overflow ('incrsaturate').";

            default sw = rw;
            default hw = na;
            default incrvalue = 1;
            default incrsaturate = true;
            default counter;

            field {desc = "Count field";} cnt[32] = 32'h0;
        };


        /* ------------------------------------------------- Registers ------------------------------------------------- */
        // First 9 registers are static and always defined                                                               //
        global_intr_en_t  global_intr_en_r;      /* 1-bit per event type */                                              //
        error_intr_en_t   error_intr_en_r;       /* 1-bit per error */                                                   //
        notif_intr_en_t   notif_intr_en_r;       /* 1-bit per notification */                                            //
        global_intr_t     error_global_intr_r;   /* 1-bit aggregating all error interrupts with global enable */         //
        global_intr_t     notif_global_intr_r;   /* 1-bit aggregating all notification interrupts with global enable */  //
        error_intr_t      error_internal_intr_r; /* Error pending, SW write 1 to clear */                                //
        notif_intr_t      notif_internal_intr_r; /* Notification pending, SW write 1 to clear */                         //
        error_intr_trig_t error_intr_trig_r;     /* SW sets error bit for interrupt testing */                           //
        notif_intr_trig_t notif_intr_trig_r;     /* SW sets notification bit for interrupt testing */                    //
                                                                                                                         //
        // Align this set of registers; number of counters is based on peripheral event requirements                     //
        intr_count_t      error_internal_intr_count_r @0x100;  /* Per error */                                           //
        intr_count_t      notif_cmd_done_intr_count_r @0x180; /* Per notification */                                     //
                                                                                                                         //
        // These registers should be treated by SW as reserved, and ignored.                                             //
        // Offset at 0x200 gives enough space for 32 Errors and 32 Notifications                                         //
        // to be implemented (requiring 2*32 32-bit registers starting at                                                //
        // offset 0x100), and still allowing the entire regfile to fit                                                   //
        // inside a 1024-byte space.                                                                                     //
        intr_count_incr_t error_internal_intr_count_incr_r @0x200; /* Per error count incrementor pulse */               //
        intr_count_incr_t notif_cmd_done_intr_count_incr_r;       /* Per notification count incrementor pulse */         //
        /* ------------------------------------------------------------------------------------------------------------- */

        /* ---- Reset assignment for Error Events ---- */
        error_internal_intr_r.error_internal_sts -> resetsignal = hard_reset_b;
        error_internal_intr_count_r.cnt          -> resetsignal = hard_reset_b;
        // TODO: Use this same reset for the error incrementor pulse too?

        /* ---- Interrupt Event Dynamic Assignments ---- */
        error_internal_intr_r.error_internal_sts -> enable = error_intr_en_r.error_internal_en;
        notif_internal_intr_r.notif_cmd_done_sts -> enable = notif_intr_en_r.notif_cmd_done_en;

        error_internal_intr_r.error_internal_sts -> next   = error_intr_trig_r.error_internal_trig;
        notif_internal_intr_r.notif_cmd_done_sts -> next   = notif_intr_trig_r.notif_cmd_done_trig;

        // NOTE: hwset for events is implicitly defined as module input

        /* ---- Global Interrupt Dynamic Assignments ---- */
        error_global_intr_r.agg_sts -> enable = global_intr_en_r.error_en;
        notif_global_intr_r.agg_sts -> enable = global_intr_en_r.notif_en;

        error_global_intr_r.agg_sts -> next = error_internal_intr_r -> intr;
        notif_global_intr_r.agg_sts -> next = notif_internal_intr_r -> intr;

        /* ---- Event Statistics Tracker Assignments ---- */
        // NOTE: This method relies upon a "counter" that is set using the
        //       same events that trigger an interrupt, then immediately
        //       self-clearing, which results in a pulse. Must be configured
        //       to be sensitive to the interrupt trigger events for each event.
        //       The output pulse is then used to increment the ACTUAL counter
        error_internal_intr_count_incr_r.pulse -> hwset    = error_internal_intr_r.error_internal_sts -> hwset; // \_____ Capture both firmware and hardware triggered events
        error_internal_intr_count_incr_r.pulse -> next     = error_internal_intr_r.error_internal_sts -> next;  // /      as a pulse to increment the intr_count_r register
        error_internal_intr_count_incr_r.pulse -> we       = error_internal_intr_r.error_internal_sts -> next;  // Generate a pulse from SW trigger, if set, or default to use the hwset input
        error_internal_intr_count_incr_r.pulse -> decr     = error_internal_intr_count_incr_r.pulse; // Auto-clear to generate pulse output
        error_internal_intr_count_r.cnt        -> incr     = error_internal_intr_count_incr_r.pulse; // Increment coincides with rising edge of interrupt sts bit

        notif_cmd_done_intr_count_incr_r.pulse -> hwset    = notif_internal_intr_r.notif_cmd_done_sts -> hwset; // \_____ Capture both firmware and hardware triggered events
        notif_cmd_done_intr_count_incr_r.pulse -> next     = notif_internal_intr_r.notif_cmd_done_sts -> next;  // /      as a pulse to increment the intr_count_r register
        notif_cmd_done_intr_count_incr_r.pulse -> we       = notif_internal_intr_r.notif_cmd_done_sts -> next;  // Generate a pulse from SW trigger, if set, or default to use the hwset input
        notif_cmd_done_intr_count_incr_r.pulse -> decr     = notif_cmd_done_intr_count_incr_r.pulse; // Auto-clear to generate pulse output
        notif_cmd_done_intr_count_r.cnt        -> incr     = notif_cmd_done_intr_count_incr_r.pulse; // Increment coincides with rising edge of interrupt sts bit

    };


    /* -----------------------
     * Register File instance
     * ----------------------- */
    intr_block_t intr_block_rf @0x800;
};
