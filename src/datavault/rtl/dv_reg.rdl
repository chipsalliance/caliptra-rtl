// SPDX-License-Identifier: Apache-2.0
//
// Licensed under the Apache License, Version 2.0 (the "License");
// you may not use this file except in compliance with the License.
// You may obtain a copy of the License at
//
// http://www.apache.org/licenses/LICENSE-2.0
//
// Unless required by applicable law or agreed to in writing, software
// distributed under the License is distributed on an "AS IS" BASIS,
// WITHOUT WARRANTIES OR CONDITIONS OF ANY KIND, either express or implied.
// See the License for the specific language governing permissions and
// limitations under the License.
//
addrmap dv_reg {
    desc="address map for keyvault";
    signal {activelow; async; cpuif_reset; field_reset;} reset_b;
    signal {activelow; async;} hard_reset_b;

    // Sticky DataVault registers
    field StickyDataVaultEntry    {desc="DataVault Entry"; sw=rw; hw=na; swwel=true; resetsignal = hard_reset_b;};
    reg StickyDataVaultReg    {StickyDataVaultEntry data[32]=0;}; //generic reg for DataVault

    // NonSticky DataVault registers (reset on warm reset)
    field NonStickyDataVaultEntry {desc="DataVault Entry"; sw=rw; hw=na; swwel=true; resetsignal = reset_b;};
    reg NonStickyDataVaultReg {NonStickyDataVaultEntry data[32]=0;}; //generic reg for DataVault

    // ============== Data Vault Registers ===========================
    reg {
        desc="Controls for the Sticky Data Vault Entries";
        field {desc="Lock writes to this entry. Writes will be suppressed when locked.";
               sw=rw; swwel=true; hw=r; resetsignal=hard_reset_b;} lock_entry=0; //Shoud reflect NONSTICKY_DV_NUM_ENTRIES from kv_defines_pkg.sv
    } StickyDataVaultCtrl[10];

    StickyDataVaultReg     STICKY_DATA_VAULT_ENTRY[10][12];//Shoud reflect STICKY_DV_NUM_ENTRIES and DV_NUM_DWORDS from kv_defines_pkg.sv

    reg {
        desc="Controls for the Non-Sticky Data Vault Entries";
        field {desc="Lock writes to this entry. Writes will be suppressed when locked.";
               sw=rw; swwel=true; hw=r; resetsignal=reset_b;} lock_entry=0; //Shoud reflect STICKY_DV_NUM_ENTRIES and DV_NUM_DWORDS from kv_defines_pkg.sv
    } NonStickyDataVaultCtrl[10];// CAREFUL with the address extensions

    NonStickyDataVaultReg  NONSTICKY_DATA_VAULT_ENTRY[10][12];//Shoud reflect NONSTICKY_DV_NUM_ENTRIES and DV_NUM_DWORDS from kv_defines_pkg.sv

    reg {
        desc="Non-Sticky Scratch Register Controls";
        field {desc="Lock writes to the Scratch registers. Writes will be suppressed when locked.";
               sw=rw; swwel=true; hw=r; resetsignal=reset_b;} lock_entry=0;
    } NonStickyLockableScratchRegCtrl[10]; //Shoud reflect NONSTICKY_SCRATCH_NUM_ENTRIES from kv_defines_pkg.sv & CAREFUL with the address extensions

    reg {
       field {sw=rw; swwel=true; hw=na; resetsignal=reset_b;} data[32]=0;
    } NonStickyLockableScratchReg[10]; //Shoud reflect NONSTICKY_LOCKQ_SCRATCH_NUM_ENTRIES from kv_defines_pkg.sv

    reg {
       field {sw=rw; hw=na; resetsignal=reset_b;} data[32]=0;
    } NonStickyGenericScratchReg[8]; //Shoud reflect NONSTICKY_SCRATCH_NUM_ENTRIES from kv_defines_pkg.sv & CAREFUL with the address extensions

    reg {
        desc="Sticky Scratch Register Controls";
        field {desc="Lock writes to the Scratch registers. Writes will be suppressed when locked.";
               sw=rw; swwel=true; hw=r; resetsignal=hard_reset_b;} lock_entry=0;
    } StickyLockableScratchRegCtrl[8]; //should reflect STICKY_LOCKQ_SCRATCH_NUM_ENTRIES

    reg {
       field {sw=rw; swwel=true; hw=na; resetsignal=hard_reset_b;} data[32]=0;
    } StickyLockableScratchReg[8]; //should reflect STICKY_LOCKQ_SCRATCH_NUM_ENTRIES

};
