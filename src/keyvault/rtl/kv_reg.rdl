// SPDX-License-Identifier: Apache-2.0
//
// Licensed under the Apache License, Version 2.0 (the "License");
// you may not use this file except in compliance with the License.
// You may obtain a copy of the License at
//
// http://www.apache.org/licenses/LICENSE-2.0
//
// Unless required by applicable law or agreed to in writing, software
// distributed under the License is distributed on an "AS IS" BASIS,
// WITHOUT WARRANTIES OR CONDITIONS OF ANY KIND, either express or implied.
// See the License for the specific language governing permissions and
// limitations under the License.
//
addrmap kv_reg {
    desc="address map for keyvault";
    signal {activelow; async; cpuif_reset; field_reset;} reset_b;
    signal {activelow; async;} hard_reset_b;

    //keys are not accessible by sw
    field key {sw=w; swwel=true; hw=rw; we=true; hwclr; resetsignal=hard_reset_b;};
    //PCR are sw accessible
    field pcr {sw=rw; swwel=true; hw=rw; we=true; hwclr;  resetsignal=hard_reset_b;};

    reg pcrReg {pcr data[32]=0;}; //generic reg for pcr
    reg keyReg {key data[32]=0;}; //generic reg for keys

    pcrReg pcr_entry[8][16];

    //controls
    reg kvCtrl {
        field {sw=rw; swwel=true; hw=r;} lock_rd=0;
        field {sw=rw; swwel=true; hw=r;} lock_wr=0;
        field {sw=rw; swwel=true; hw=r;} lock_use=0;
        field {sw=rw; hw=r; singlepulse;} clear=0;
        //field {sw=rw; hw=r; hwclr;} copy[4];
        //field {sw=rw; hw=r;} copy_dest[8:5];
        field {sw=r; hw=rw; we=true;} dest_valid[14:9]=7;
        field {sw=rw; hw=na;} rsvd[31:15]=0;
    };

    kvCtrl key_ctrl[8];
    kvCtrl pcr_ctrl[8];

    //stick these at the end since sw won't actually address them ever
    keyReg key_entry[8][16];
};
