// SPDX-License-Identifier: Apache-2.0
//
// Licensed under the Apache License, Version 2.0 (the "License");
// you may not use this file except in compliance with the License.
// You may obtain a copy of the License at
//
// http://www.apache.org/licenses/LICENSE-2.0
//
// Unless required by applicable law or agreed to in writing, software
// distributed under the License is distributed on an "AS IS" BASIS,
// WITHOUT WARRANTIES OR CONDITIONS OF ANY KIND, either express or implied.
// See the License for the specific language governing permissions and
// limitations under the License.
//
addrmap kv_reg {
    desc="address map for keyvault";
    signal {activelow; async; cpuif_reset; field_reset;} reset_b;
    signal {activelow; async;} core_only_rst_b;
    signal {activelow; async;} hard_reset_b;

    //keys are not accessible by sw
    field key {desc="Key Entries are not accessible by software"; sw=w; swwel=true; hw=rw; we=true; hwclr; resetsignal = hard_reset_b;};
    reg keyReg {desc="Key Entries are not readable or writeable by software"; key data[32]=0;}; //generic reg for keys

    //controls
    reg kvCtrl {
       desc="Controls for each keyvault and pcr entry";
       field {desc="Lock writes to this entry. Writes will be suppressed and an error will be recorded.";
              sw=rw; swwel=true; hw=r; resetsignal=core_only_rst_b;} lock_wr=0; //warm reset
       field {desc="Lock use of this entry. Reads will be suppressed and an error will be recorded.";
              sw=rw; swwel=true; hw=r; resetsignal=core_only_rst_b;} lock_use=0; //warm reset
       field {desc="Clear the data stored in this entry. Lock write will prevent this clear.";
              sw=rw; hw=r; singlepulse;} clear=0;
       field {desc="Reserved";
              sw=rw; hw=r; hwclr;} rsvd0=0; //copy enhancement
       field {desc="Reserved";
              sw=rw; hw=r;} rsvd1[5]=0; //copy_dest enhancement
       field {desc="Destination valid bits stored as an array for ease of use in RTL.
              [br]dest_valid[0] = hmac_key_dest_valid
              [br]dest_valid[1] = hmac_block_dest_valid
              [br]dest_valid[2] = sha_block_dest_valid
              [br]dest_valid[3] = ecc_pkey_dest_valid
              [br]dest_valid[4] = ecc_seed_dest_valid
              [br]dest_valid[5] = rsvd
              [br]dest_valid[6] = rsvd
              [br]dest_valid[7] = rsvd";
              sw=r; hw=rw; we=true; hwclr; resetsignal = hard_reset_b;} dest_valid[6]=0;
       field {desc = "Stores the offset of the last valid dword, used to indicate last cycle on reads.";
              sw=r; hw=rw; we=true; hwclr; resetsignal = hard_reset_b;} last_dword[4]=0;
    };

    // Implies we have KV_NUM_KEYS entries of each 64B of width
    kvCtrl KEY_CTRL[32] @0x00000000;//Shoud reflect KV_NUM_KEYS from kv_defines_pkg.sv
    //stick these at the end since sw won't actually address them ever
    keyReg KEY_ENTRY[32][12] @0x00000600;//Shoud reflect KV_NUM_KEYS from kv_defines_pkg.sv

    reg {
        field {desc="Fill the keyvault with debug values"; sw=rw; hw=r; singlepulse;} wr_debug_values=0;
        field {desc="Selects between debug value 0 or 1 parameter to write to keyvault"; sw=rw; hw=r;} sel_debug_value=0;
    } CLEAR_SECRETS @0x00000C00;
        
};
