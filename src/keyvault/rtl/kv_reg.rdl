// SPDX-License-Identifier: Apache-2.0
//
// Licensed under the Apache License, Version 2.0 (the "License");
// you may not use this file except in compliance with the License.
// You may obtain a copy of the License at
//
// http://www.apache.org/licenses/LICENSE-2.0
//
// Unless required by applicable law or agreed to in writing, software
// distributed under the License is distributed on an "AS IS" BASIS,
// WITHOUT WARRANTIES OR CONDITIONS OF ANY KIND, either express or implied.
// See the License for the specific language governing permissions and
// limitations under the License.
//
addrmap kv_reg {
    desc="address map for keyvault";
    signal {activelow; async; cpuif_reset; field_reset;} hard_reset_b;
    //signal {activelow; async;} hard_reset_b;

    //keys are not accessible by sw
    field key {desc="Key Entries are not accessible by software"; sw=w; swwel=true; hw=rw; we=true; hwclr;};
    //PCR are sw accessible
    field pcr {desc="PCR Entries"; sw=rw; swwel=true; hw=rw; we=true; hwclr;};

    reg pcrReg {pcr data[32]=0;}; //generic reg for pcr
    reg keyReg {desc="Key Entries are not readable or writeable by software"; key data[32]=0;}; //generic reg for keys


    //controls
    reg kvCtrl {
        desc="Controls for each keyvault and pcr entry";
        field {sw=rw; swwel=true; hw=r; hwclr;} lock_rd=0;
        field {sw=rw; swwel=true; hw=r; hwclr;} lock_wr=0;
        field {sw=rw; swwel=true; hw=r; hwclr;} lock_use=0;
        field {sw=rw; hw=r; singlepulse;} clear=0;
        //field {sw=rw; hw=r; hwclr;} copy[4];
        //field {sw=rw; hw=r;} copy_dest[8:5];
        field {sw=r; hw=rw; we=true; hwclr;} dest_valid[14:9]=0;
        field {sw=rw; hw=na;} rsvd[31:15]=0;
    };

    kvCtrl PCR_CTRL[8];
    pcrReg PCR_ENTRY[8][16] @0x00000200;

    kvCtrl KEY_CTRL[8] @0x00000400;
    //stick these at the end since sw won't actually address them ever
    keyReg KEY_ENTRY[8][16] @0x00000600;

    reg {
        field {desc="Fill the keyvault with debug values"; sw=rw; hw=r; singlepulse;} wr_debug_values=0;
        field {desc="Selects between debug value 0 or 1 parameter to write to keyvault"; sw=rw; hw=r;} sel_debug_value=0;
    } CLEAR_SECRETS @0x00000800;
};
