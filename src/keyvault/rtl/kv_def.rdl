// SPDX-License-Identifier: Apache-2.0
//
// Licensed under the Apache License, Version 2.0 (the "License");
// you may not use this file except in compliance with the License.
// You may obtain a copy of the License at
//
// http://www.apache.org/licenses/LICENSE-2.0
//
// Unless required by applicable law or agreed to in writing, software
// distributed under the License is distributed on an "AS IS" BASIS,
// WITHOUT WARRANTIES OR CONDITIONS OF ANY KIND, either express or implied.
// See the License for the specific language governing permissions and
// limitations under the License.
//
   reg kv_status_reg {
        name = "Key Vault Status Register";
        desc = "Reports the Key Vault flow status for this engine";

        field {desc = "Key Vault control is ready for use"; sw=r; hw=w;} READY = 1'b0;
        field {desc = "Key Vault flow is done"; sw=r; hw=na; hwset; hwclr;} VALID = 1'b0;
        field {
            name = "Key Vault Error";
            desc = "Indicates the error status of a key vault flow";

            enum kv_error_e {
                SUCCESS = 8'h00 {
                    desc = "Key Vault flow was successful";
                };
                KV_READ_FAIL = 8'h01 {
                    desc = "Key Vault Read flow failed";
                };
                KV_WRITE_FAIL = 8'h02 {
                    desc = "Key Vault Write flow failed";
                };
            };
            sw=r; hw=w; encode = kv_error_e;} ERROR[8]=0;
    };

    reg kv_read_ctrl_reg #(longint unsigned KV_ENTRY_ADDRESS_W = 5) {
        name = "Key Vault Read Control Register";
        desc = "Controls the Key Vault read access for this engine";

        default sw = rw;
        default hw = r;

        field {desc = "Indicates that the read data is to come from the key vault.
                       Setting this bit to 1 initiates copying of data from the key vault."; hwclr;} read_en = 0;
        field {desc = "Key Vault entry to retrieve the read data from for the engine";} read_entry[KV_ENTRY_ADDRESS_W] = 0;    
        field {desc = "Requested entry is a PCR. This is used only for SHA to hash extend, it's NOP in all other engines";} pcr_hash_extend = 0;
        field {desc = "Reserved field";} rsvd[25] = 0;

    };

    reg kv_write_ctrl_reg #(longint unsigned KV_ENTRY_ADDRESS_W = 5) {
        name = "Key Vault Write Control Register";
        desc = "Controls the Key Vault write access for this engine";

        default sw = rw;
        default hw = r;

        field {desc = "Indicates that the result is to be stored in the key vault.
                       Setting this bit to 1 will copy the result to the keyvault when it is ready."; hwclr;} write_en = 0;
        field {desc = "Key Vault entry to store the result";} write_entry[KV_ENTRY_ADDRESS_W] = 0;
        field {desc = "HMAC KEY is a valid destination";} hmac_key_dest_valid = 0;
        field {desc = "HMAC BLOCK is a valid destination";} hmac_block_dest_valid = 0;
        field {desc = "SHA BLOCK is a valid destination";} sha_block_dest_valid = 0;
        field {desc = "ECC PKEY is a valid destination";} ecc_pkey_dest_valid = 0;
        field {desc = "ECC SEED is a valid destination";} ecc_seed_dest_valid = 0;
        field {desc = "Reserved field";} rsvd[21] = 0;

    };
