// SPDX-License-Identifier: Apache-2.0
//
// Licensed under the Apache License, Version 2.0 (the "License");
// you may not use this file except in compliance with the License.
// You may obtain a copy of the License at
//
// http://www.apache.org/licenses/LICENSE-2.0
//
// Unless required by applicable law or agreed to in writing, software
// distributed under the License is distributed on an "AS IS" BASIS,
// WITHOUT WARRANTIES OR CONDITIONS OF ANY KIND, either express or implied.
// See the License for the specific language governing permissions and
// limitations under the License.
//
addrmap pv_reg {
    desc="address map for pcrvault";
    signal {activelow; async; cpuif_reset; field_reset;} reset_b;
    signal {activelow; async;} core_only_rst_b;
    signal {activelow; async;} hard_reset_b;

    //PCR are sw read only
    field pcr {desc="PCR Entries"; sw=r; hw=rw; we=true; hwclr; resetsignal = hard_reset_b;};

    reg pcrReg {desc="Pcr Entries are read only"; pcr data[32]=0;}; //generic reg for pcrs

    //controls
    reg pvCtrl {
        desc="Controls for each pcr entry";
        field {desc="Lock the PCR from being cleared";
               sw=rw; swwel=true; hw=r; resetsignal = core_only_rst_b;} lock=0; 
        field {desc="Clear the data stored in this entry. Lock will prevent this clear.";
               sw=rw; swwel=true; hw=r; singlepulse;} clear=0;
        field {desc="Reserved";
               sw=rw; hw=r; hwclr;} rsvd0=0; //copy enhancement
        field {desc="Reserved";
               sw=rw; hw=r;} rsvd1[7:3]=0; //copy_dest enhancement
    };

    // Implies we have PV_NUM_PCR entries of each 48B of width
    pvCtrl PCR_CTRL[32]; //Shoud reflect PV_NUM_PCR from pv_defines_pkg.sv
    pcrReg PCR_ENTRY[32][12] @0x00000600;//Shoud reflect PV_NUM_PCR from pv_defines_pkg.sv

};
