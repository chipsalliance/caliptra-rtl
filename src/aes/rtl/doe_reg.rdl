// SPDX-License-Identifier: Apache-2.0
//
// Licensed under the Apache License, Version 2.0 (the "License");
// you may not use this file except in compliance with the License.
// You may obtain a copy of the License at
//
// http://www.apache.org/licenses/LICENSE-2.0
//
// Unless required by applicable law or agreed to in writing, software
// distributed under the License is distributed on an "AS IS" BASIS,
// WITHOUT WARRANTIES OR CONDITIONS OF ANY KIND, either express or implied.
// See the License for the specific language governing permissions and
// limitations under the License.
//


addrmap doe_reg {
    desc="address maps for DOE register space";


    addressing = regalign; // This is the default if not specified
    lsb0 = true; // lsb0 property is implicit/default. See docs for
                 // SystemRDL 2.0 sections 9.1 and 13.4

    default hw = na;
    signal {activelow; async; cpuif_reset; field_reset;} reset_b;

    /* -----------------------
    * Register definitive definitions
    * ----------------------- */

    /* ---- DOE Component Name ---- */
    reg {
        name = "DOE component name register type definition";
        desc = "Two 32-bit read-only registers repereseting of the name
                of DOE component. These registers are located at
                DOE_base_address + 0x0000_0000 and 0x0000_0004 addresses.";

        default sw = r;
        default hw = w;
        field {desc = "Name field";} NAME[32];

    } DOE_NAME[2] @0x00000000;



    /* ---- DOE Component Version ---- */
    reg {
        name = "DOE component version register type definition";
        desc = "Two 32-bit read-only registers repereseting of the version
                of DOE component. These registers are located at
                DOE_base_address + 0x0000_0008 and 0x0000_000C addresses.";

        default sw = r;
        default hw = w;
        field {desc = "Version field";} VERSION[32];
        
    } DOE_VERSION[2] @0x00000008;



    /* ---- DOE Component Control ---- */
    reg {
        name = "DOE component control register type definition";
        desc = "One 2-bit register including the following flags: 
                bit #0: INIT : Trigs the DOE core to start the 
                                processing for the key and the first padded 
                                message block.
                bit #1: NEXT: ​Trigs the DOE core to start the 
                                processing for the remining padded message block. 
                This register is located at DOE_base_address + 0x0000_0010
                After each software write, hardware will erase the register.";

        default sw = w;
        default hw = rw;
        default resetsignal = reset_b;
        field {desc = "Control init command bit";} INIT = 1'b0;
        field {desc = "Control next command bit";} NEXT = 1'b0;
    
    } DOE_CTRL @0x00000010;



    /* ---- DOE Component Status ---- */
    reg {
        name = "DOE component status register type definition";
        desc = "One 2-bit register including the following flags: 
                bit #0: READY : ​Indicates if the core is ready to take
                                a control command and process the block.  
                bit #1: Valid: ​Indicates if the process is done and the
                                results stored in RESULT registers are valid. 
                This register is located at DOE_base_address + 0x0000_0018.";

        default sw = r;
        default hw = w;
        default resetsignal = reset_b;
        field {desc = "Status ready bit";} READY = 1'b0;
        field {desc = "Status valid bit";} VALID = 1'b0;
    
    } DOE_STATUS @0x00000018;


    
    /* ---- DOE Component Input Key ---- */
    reg {
        name = "DOE component key register type definition";
        desc = "8 32-bit registers storing the 256-bit key.
                These registers are located at DOE_base_address + 
                0x0000_0040 to 0x0000_005C in big-endian representation.";

        default sw = w;
        default hw = r;
        default resetsignal = reset_b;
        field {desc = "Input DOE key field";} KEY[32] = 32'b0;
    
    } DOE_KEY[12] @0x00000040;



    /* ---- DOE Component Input Message Block ---- */
    reg {
        name = "DOE component block register type definition";
        desc = "4 32-bit registers storing the 128-bit padded input.
                These registers are located at DOE_base_address + 
                0x0000_0080 to 0x0000_008C in big-endian representation.";

        default sw = w;
        default hw = r;
        default resetsignal = reset_b;
        field {desc = "Input message block field";} BLOCK[32] = 32'b0;
    
    } DOE_BLOCK[8] @0x00000080;

    

    /* ---- DOE Component Output Result ---- */
    reg {
        name = "DOE component result register type definition";
        desc = "4 32-bit registers storing the 128-bit digest output.
                These registers are located at DOE_base_address + 
                0x0000_0100 to 0x0000_010C in big-endian representation.";

        default sw = r;
        default hw = w;
        default resetsignal = reset_b;
        field {desc = "Result of DOE operation";} RESULT[32] = 32'b0;
    
    } DOE_RESULT[4] @0x00000100;

    /* ---- DOE Component IV  ---- */
    reg {
        name = "DOE component IV register type definition";
        desc = "4 32-bit registers storing the 128-bit IV.
                These registers are located at DOE_base_address + 
                0x0000_0110 to 0x0000_011c in big-endian representation.";

        default sw = r;
        default hw = w;
        default resetsignal = reset_b;
        field {desc = "IV input field";} IV[32] = 32'b0;
    
    } DOE_IV[4] @0x00000110;

    /* ---- DOE Key Vault Control Reg ---- */
    reg {
        name = "DOE Key Vault Control Register";
        desc = "Controls the Key Vault access for DOE";

        default sw = rw;
        default hw = r;
        default resetsignal = reset_b;


        field {
            desc = "Indicates the command for DOE to run";

            enum doe_cmd_e {
                DOE_IDLE = 2'd0 {
                    desc = "DOE is in idle state.";
                };
                DOE_UDS = 2'd1 {
                    desc = "Request DOE to run UDS flow.";
                };
                DOE_FE = 2'd2 {
                    desc = "Request DOE to run FE flow.";
                };
                DOE_NA = 2'd3 {
                    desc = "NA";
                };
            };
            encode = doe_cmd_e;} CMD[2]=0;
        field {desc = "Key Vault entry to store the result.";} DEST[3] = 0;
        field {desc = "Selected DOE Flow is Done";} FLOW_DONE = 0;

    } DOE_KV_CTRL @0x00000200;
};