addrmap mbox_reg {
    desc="address maps for mbox arch register and fuse space";
    default hw = na;
    signal {activelow; async; cpuif_reset; field_reset;} reset_b;
    signal {activelow; async;} hard_reset_b;
    //signal to indicate request is coming from soc side
    signal {} soc_req;

    //defined fields by access type
    //first is uc access type, second is soc access type
    field rw_ro {swwel = soc_req;}; //writes enabled only for uc
    field ro_rw {swwe  = soc_req;}; //writes enabled only for soc
    field ro_ro {sw = r;};
    field rw_rw { };

    //TODO reset domain for fuses
    field fuse {sw = rw1; hw = r; resetsignal = hard_reset_b;};
    field secret {sw = w1; hw = r; hwclr; resetsignal = hard_reset_b;};
    field key {sw = w; swwe; hw = rw; wel; hwclr;};

    reg {rw_ro error_code[32]=0;} HW_ERROR_FATAL;
    reg {rw_ro error_code[32]=0;} HW_ERROR_NON_FATAL;
    reg {rw_ro error_code[32]=0;} FW_ERROR_FATAL;
    reg {rw_ro error_code[32]=0;} FW_ERROR_NON_FATAL;
    reg {rw_ro error_code[32]=0;} HW_ERROR_ENC;
    reg {rw_ro error_code[32]=0;} FW_ERROR_ENC;
    reg {rw_ro status[32]=0;} BOOT_STATUS;
    reg {rw_ro status[30]=0;
         field {sw=rw; swwel = soc_req; hw=r;} ready_for_fw[1]=0;
         field {sw=rw; swwel = soc_req; hw=r;} ready_for_runtime[1]=0;} FLOW_STATUS;

    reg {field {sw=w; swwel = soc_req; hw=r; singlepulse;} clear=0;} CLEAR_SECRETS;

    reg {field {sw=rw; hw=w;} generic_wires[32];} generic_input_wires[2];
    reg {field {sw=rw; hw=r;} generic_wires[32];} generic_output_wires[2];


    //fuses
    reg {secret seed[32]=0;} uds_seed[12] @0x200;
    reg {secret seed[32]=0;} field_entropy[32];
    //TODO review write once and stickiness of fuses
    reg {fuse hash[32]=0;} key_manifest_pk_hash_0[12];
    reg {fuse hash[32]=0;} key_manifest_pk_hash_1[12];
    reg {fuse hash[32]=0;} key_manifest_pk_hash_2[12];
    reg {fuse hash[32]=0;} key_manifest_pk_hash_3[12];
    reg {fuse mask[4]=0;} key_manifest_pk_hash_mask;
    reg {fuse svn[32]=0;} key_manifest_svn;
    reg {fuse svn[32]=0;} boot_loader_svn;
    reg {fuse svn[32]=0;} runtime_svn[4];
    reg {fuse dis[1]=0;} anti_rollback_disable;
    reg {fuse cert[32]=0;} ieee_idevid_cert_chain;
    reg {fuse done[1]=0;} fuse_done;

    reg {key key[32];} obf_key[8];


};