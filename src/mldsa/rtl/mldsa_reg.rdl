// SPDX-License-Identifier: Apache-2.0
//
// Licensed under the Apache License, Version 2.0 (the "License");
// you may not use this file except in compliance with the License.
// You may obtain a copy of the License at
//
// http://www.apache.org/licenses/LICENSE-2.0
//
// Unless required by applicable law or agreed to in writing, software
// distributed under the License is distributed on an "AS IS" BASIS,
// WITHOUT WARRANTIES OR CONDITIONS OF ANY KIND, either express or implied.
// See the License for the specific language governing permissions and
// limitations under the License.
//


addrmap mldsa_reg {
    desc="address maps for adams bridge register space";


    addressing = regalign; // This is the default if not specified
    lsb0 = true; // lsb0 property is implicit/default. See docs for
                 // SystemRDL 2.0 sections 9.1 and 13.4

    default hw = na;
    signal {activelow; async; cpuif_reset; field_reset;} reset_b;
    signal {activelow; async;} hard_reset_b;
    signal {} mldsa_ready;


    /* -----------------------
    * Register definitive definitions
    * ----------------------- */

    /* ---- MLDSA Component Name ---- */
    reg {
        name = "MLDSA component name register type definition";
        desc = "Two 32-bit read-only registers representing of the name
                of MLDSA component.";

        default sw = r;
        default hw = w;
        field {desc = "Name field";} NAME[32];

    } MLDSA_NAME[2];



    /* ---- MLDSA Component Version ---- */
    reg {
        name = "MLDSA component version register type definition";
        desc = "Two 32-bit read-only registers representing of the version
                of MLDSA component.";

        default sw = r;
        default hw = w;
        field {desc = "Version field";} VERSION[32];
        
    } MLDSA_VERSION[2];



    /* ---- MLDSA Component Control ---- */
    reg {
        name = "MLDSA component control register type definition";
        desc = "Control register to set the type of MLDSA operations.
                [br] bit #[1:0]: This can be: 
                [br]            000 for NONE
                [br]            001 for KEYGEN
                [br]            010 for SIGNING
                [br]            011 for VERIFYING
                [br]            100 for KEYGEN+SIGN

                [br] bit #3: Zeroize all internal registers after MLDSA process, to avoid SCA leakage.
                ";

        default sw = w;
        default hw = r;
        default resetsignal = reset_b;
        field {desc = "Control command field"; swwe = mldsa_ready; hwclr;} CTRL[3] = 3'b0;
        field {desc = "Zeroize all internal registers"; singlepulse;} ZEROIZE = 1'b0;
    
    } MLDSA_CTRL;



    /* ---- MLDSA Component Status ---- */
    reg {
        name = "MLDSA component status register type definition";
        desc = "One 2-bit register including the following flags: 
                bit #0: READY : ​Indicates if the core is ready to take
                                a control command and process the inputs.  
                bit #1: VALID : ​Indicates if the process is done and the
                                result is valid. 
                ";

        default sw = r;
        default hw = w;
        default resetsignal = reset_b;
        field {desc = "Status ready bit";} READY = 1'b0;
        field {desc = "Status valid bit";} VALID = 1'b0;
    
    } MLDSA_STATUS;


    /* ---- MLDSA Component Input ENTROPY ---- */
    reg {
        name = "MLDSA component entropy register type definition";
        desc = "16 32-bit registers storing the 512-bit entropy  in big-endian representation
                required for SCA countermeasures with no change on the outputs. 
                The entropy can be any 512-bit value in [0 : 2^512-1].";

        default sw = w;
        default hw = r;
        default resetsignal = reset_b;
        field {desc = "Input entropy field"; swwe = mldsa_ready; hwclr;} ENTROPY[32] = 32'b0;
    
    } MLDSA_ENTROPY[16];

    /* ---- MLDSA Component Input SEED ---- */
    reg {
        name = "MLDSA component seed register type definition";
        desc = "8 32-bit registers storing the 256-bit seed for keygen in big-endian representation.
                The seed can be any 256-bit value in [0 : 2^256-1].";

        default sw = w;
        default hw = rw;
        default we = true;
        default resetsignal = reset_b;
        field {desc = "Input seed field"; swwe = mldsa_ready; hwclr;} SEED[32] = 32'b0;
    
    } MLDSA_SEED[8];

    
    /* ---- MLDSA Component Input sign_rnd ---- */
    reg {
        name = "MLDSA component sign_rnd register type definition";
        desc = "8 32-bit registers storing the 256-bit sign_rnd for signing in big-endian representation.
                The sign_rnd can be any 256-bit value in [0 : 2^256-1].
                sign_rnd should be all zero for deterministic variant.";

        default sw = w;
        default hw = r;
        default resetsignal = reset_b;
        field {desc = "Input sign_rnd field"; swwe = mldsa_ready; hwclr;} SIGN_RND[32] = 32'b0;
    
    } MLDSA_SIGN_RND[8];


    /* ---- MLDSA Component Input Message ---- */
    reg {
        name = "MLDSA component hashed message register type definition";
        desc = "16 32-bit registers storing the hash of the message in big-endian representation.
                The hashed message can be any 512-bit value in [0 : 2^512-1].";

        default sw = w;
        default hw = rw;
        default we = true;
        default resetsignal = reset_b;
        field {desc = "Input message field"; swwe = mldsa_ready; hwclr;} MSG[32] = 32'b0;
    
    } MLDSA_MSG[16];


    /* ---- MLDSA Component Verify Result ---- */
    reg {
        name = "MLDSA component verify result register type definition";
        desc = "16 32-bit registers storing the result of verifying operation in big-endian representation.
                If this register is equal to the first part of the given signature, i.e. c~,
                the signature is verified.";

        default sw = r;
        default hw = rw;
        default we = true;
        default resetsignal = reset_b;
        field {desc = "Output verify result field"; hwclr;} VERIFY_RES[32] = 32'b0;
    
    } MLDSA_VERIFY_RES[16];

    /* ---- MLDSA Component Public Key ---- */
    external reg {
        name = "MLDSA component public key register type definition";
        desc = "648 32-bit registers storing the public key in big-endian representation. 
                These registers are read by MLDSA user after keygen operation, 
                or set before verifying operation.";

        default sw = rw;
        default hw = rw;
        default we = true;
        default resetsignal = reset_b;
        field {desc = "Public key field"; swwe = mldsa_ready; hwclr;} PUBKEY[32] = 32'b0;
    
    } MLDSA_PUBKEY[648];
    
    /* ---- MLDSA Component Signature ---- */
    external reg {
        name = "MLDSA component signature register type definition";
        desc = "1157 32-bit registers storing the signature of the message in big-endian representation. 
                These registers are read by MLDSA user after signing operation, 
                or set before verifying operation.";

        default sw = rw;
        default hw = rw;
        default we = true;
        default resetsignal = reset_b;
        field {desc = "Signature field"; swwe = mldsa_ready; hwclr;} SIGNATURE[32] = 32'b0;
    
    } MLDSA_SIGNATURE[1157];

    /* ---- MLDSA Component Private Key OUT---- */
    external mem {
        name = "MLDSA component private key output register type definition";
        desc = "1224 32-bit registers storing the private key for keygen in big-endian representation.
                These registers are read by MLDSA user after keygen operation.";

        sw = r;
        mementries = 1224;
        memwidth = 32;
    } MLDSA_PRIVKEY_OUT;

    /* ---- MLDSA Component Private Key IN---- */
    external mem {
        name = "MLDSA component private key input register type definition";
        desc = "1224 32-bit entries storing the private key for signing in big-endian representation. 
                These entries must be set before signing operation.";

        sw = w;
        mementries = 1224;
        memwidth = 32;
    } MLDSA_PRIVKEY_IN;


    ////////////////////////////////////////////////////////////////
    // Interrupts
    /* -----------------------
     * Register File definitive definition
     * ----------------------- */

    // Notifications are non-error events that occur during normal operation of the module.
    // E.g. a completion of a job may produce a notification.
    // Error and notification events are separated into separate status/trigger registers
    // to allow effective priority allocation by software
    regfile intr_block_t {


        /* -----------------------
         * Default properties for Register File
         * ----------------------- */

        name = "Interrupt Register Block";
        desc = "Set of registers to implement interrupt functionality
                for MLDSA";

        default regwidth = 32; // reg property
        default accesswidth = 32; // reg property
        default hw = na; // field property


        /* -----------------------
         * Register definitive definitions
         * ----------------------- */

        /* ---- Global Interrupt Enable ---- */
        reg global_intr_en_t {
            name = "Per-Type Interrupt Enable Register";
            desc = "Dedicated register with one bit for each event type that may produce an interrupt.";

            default hw = na;
            default sw = rw;

            // Global enablement (for interrupts of the event types defined for this module)
            field {desc = "Global enable bit for all events of type 'Error'";       } error_en = 1'b0;
            field {desc = "Global enable bit for all events of type 'Notification'";} notif_en = 1'b0;
        };

        /* ---- Error Interrupt Enable ---- */
        reg error_intr_en_t {
            name = "Per-Event Interrupt Enable Register";
            desc = "Dedicated register with one bit for each event that may produce an interrupt.";

            default hw = na;
            default sw = rw;

            // Specific enables for the events defined in this
            // event type in the instantiating peripheral.
            // TODO: Add en, sts, trig, cnt for all tracked errors
            field {desc = "Enable bit for Internal Errors";               } error_internal_en = 1'b0;
        };

        /* ---- Notification Interrupt Enable ---- */
        reg notif_intr_en_t {
            name = "Per-Event Interrupt Enable Register";
            desc = "Dedicated register with one bit for each event that may produce an interrupt.";

            default hw = na;
            default sw = rw;

            // Specific enables for the events defined in this
            // event type in the instantiating peripheral.
            field {desc = "Enable bit for Command Done";} notif_cmd_done_en = 1'b0;
        };

        /* ---- Error Interrupt Status ---- */
        reg error_intr_t {
            name = "Interrupt Status Register type definition";
            desc = "Single bit indicating occurrence of each interrupt event.
                    Sticky, level assertion, write-1-to-clear.";

            default precedence = hw;
            default hw = w;
            default hwset = true;
            default sw = rw;
            default woclr = true;
            default level intr;

            field {desc = "Internal Errors status bit";                 } error_internal_sts = 1'b0;
        };

        /* ---- Notification Interrupt Status ---- */
        reg notif_intr_t {
            name = "Interrupt Status Register type definition";
            desc = "Single bit indicating occurrence of each interrupt event.
                    Sticky, level assertion, write-1-to-clear.";

            default precedence = hw;
            default hw = w;
            default hwset = true;
            default sw = rw;
            default woclr = true;
            default level intr;

            field {desc = "Command Done status bit";} notif_cmd_done_sts = 1'b0;
        };

        /* ---- Aggregated Interrupt Status ---- */
        reg global_intr_t {
            name = "Interrupt Status Aggregation Register type definition";
            desc = "Single bit indicating occurrence of any interrupt event
                    of a given type. E.g. Notifications and Errors may drive
                    to two separate interrupt registers. There may be
                    multiple sources of Notifications or Errors that are
                    aggregated into a single interrupt pin for that
                    respective type. That pin feeds through this register
                    in order to apply a global enablement of that interrupt
                    event type.
                    Nonsticky assertion.";

            default hw = w;
            default sw = r;
            default nonsticky intr;

            field {desc = "Interrupt Event Aggregation status bit";} agg_sts = 1'b0;
        };

        /* ---- Error Interrupt Trigger ---- */
        reg error_intr_trig_t {
            name = "Interrupt Trigger Register type definition";
            desc = "Single bit for each interrupt event allows SW to manually
                    trigger occurrence of that event. Upon SW write, the trigger bit
                    will pulse for 1 cycle then clear to 0. The pulse on the
                    trigger register bit results in the corresponding interrupt
                    status bit being set to 1.";

            default hw = na;
            default sw = rw;
            default woset = true;
            default singlepulse = true;

            // Instantiate triggers bit-by-bit.
            field {desc = "Internal Errors trigger bit";               } error_internal_trig = 1'b0;
        };

        /* ---- Notification Interrupt Trigger ---- */
        reg notif_intr_trig_t {
            name = "Interrupt Trigger Register type definition";
            desc = "Single bit for each interrupt event allows SW to manually
                    trigger occurrence of that event. Upon SW write, the trigger bit
                    will pulse for 1 cycle then clear to 0. The pulse on the
                    trigger register bit results in the corresponding interrupt
                    status bit being set to 1.";

            default hw = na;
            default sw = rw;
            default woset = true;
            default singlepulse = true;

            // Instantiate triggers bit-by-bit.
            field {desc = "Command Done trigger bit";} notif_cmd_done_trig = 1'b0;
        };

        /* ---- Interrupt Statistics Counter Incrementor ---- */
        reg intr_count_incr_t {
            name = "Interrupt Event Count Incrementor";
            desc = "Trigger the event counter to increment based on observing
                    the rising edge of an interrupt event input from the
                    Hardware. The same input signal that causes an interrupt
                    event to be set (sticky) also causes this signal to pulse
                    for 1 clock cycle, resulting in the event counter
                    incrementing by 1 for every interrupt event.
                    This is implemented as a down-counter (1-bit) that will
                    decrement immediately on being set - resulting in a pulse";

            default hw = w;
            default sw = r; // Has to have some access.... ideally SW wouldn't even see this
            default hwset = true;
            default decrvalue = 1;
            default counter;

            field {desc = "Pulse mirrors interrupt event occurrence";} pulse = 1'b0;
        };

        /* ---- Interrupt Statistics Counter ---- */
        reg intr_count_t {
            name = "Interrupt Event Counter";
            desc = "Provides statistics about the number of events that have
                    occurred.
                    Will not overflow ('incrsaturate').";

            default sw = rw;
            default hw = na;
            default incrvalue = 1;
            default incrsaturate = true;
            default counter;

            field {desc = "Count field";} cnt[32] = 32'h0;
        };


        /* ------------------------------------------------- Registers ------------------------------------------------- */
        // First 9 registers are static and always defined                                                               //
        global_intr_en_t  global_intr_en_r;      /* 1-bit per event type */                                              //
        error_intr_en_t   error_intr_en_r;       /* 1-bit per error */                                                   //
        notif_intr_en_t   notif_intr_en_r;       /* 1-bit per notification */                                            //
        global_intr_t     error_global_intr_r;   /* 1-bit aggregating all error interrupts with global enable */         //
        global_intr_t     notif_global_intr_r;   /* 1-bit aggregating all notification interrupts with global enable */  //
        error_intr_t      error_internal_intr_r; /* Error pending, SW write 1 to clear */                                //
        notif_intr_t      notif_internal_intr_r; /* Notification pending, SW write 1 to clear */                         //
        error_intr_trig_t error_intr_trig_r;     /* SW sets error bit for interrupt testing */                           //
        notif_intr_trig_t notif_intr_trig_r;     /* SW sets notification bit for interrupt testing */                    //
                                                                                                                         //
        // Align this set of registers; number of counters is based on peripheral event requirements                     //
        intr_count_t      error_internal_intr_count_r @0x100;  /* Per error */                                           //
        intr_count_t      notif_cmd_done_intr_count_r @0x180; /* Per notification */                                     //
                                                                                                                         //
        // These registers should be treated by SW as reserved, and ignored.                                             //
        // Offset at 0x200 gives enough space for 32 Errors and 32 Notifications                                         //
        // to be implemented (requiring 2*32 32-bit registers starting at                                                //
        // offset 0x100), and still allowing the entire regfile to fit                                                   //
        // inside a 1024-byte space.                                                                                     //
        intr_count_incr_t error_internal_intr_count_incr_r @0x200; /* Per error count incrementor pulse */               //
        intr_count_incr_t notif_cmd_done_intr_count_incr_r;       /* Per notification count incrementor pulse */         //
        /* ------------------------------------------------------------------------------------------------------------- */

        /* ---- Reset assignment for Error Events ---- */
        error_internal_intr_r.error_internal_sts -> resetsignal = hard_reset_b;
        error_internal_intr_count_r.cnt          -> resetsignal = hard_reset_b;
        // TODO: Use this same reset for the error incrementor pulse too?

        /* ---- Interrupt Event Dynamic Assignments ---- */
        error_internal_intr_r.error_internal_sts -> enable = error_intr_en_r.error_internal_en;
        notif_internal_intr_r.notif_cmd_done_sts -> enable = notif_intr_en_r.notif_cmd_done_en;

        error_internal_intr_r.error_internal_sts -> next   = error_intr_trig_r.error_internal_trig;
        notif_internal_intr_r.notif_cmd_done_sts -> next   = notif_intr_trig_r.notif_cmd_done_trig;

        // NOTE: hwset for events is implicitly defined as module input

        /* ---- Global Interrupt Dynamic Assignments ---- */
        error_global_intr_r.agg_sts -> enable = global_intr_en_r.error_en;
        notif_global_intr_r.agg_sts -> enable = global_intr_en_r.notif_en;

        error_global_intr_r.agg_sts -> next = error_internal_intr_r -> intr;
        notif_global_intr_r.agg_sts -> next = notif_internal_intr_r -> intr;

        /* ---- Event Statistics Tracker Assignments ---- */
        // NOTE: This method relies upon a "counter" that is set using the
        //       same events that trigger an interrupt, then immediately
        //       self-clearing, which results in a pulse. Must be configured
        //       to be sensitive to the interrupt trigger events for each event.
        //       The output pulse is then used to increment the ACTUAL counter
        error_internal_intr_count_incr_r.pulse -> hwset    = error_internal_intr_r.error_internal_sts -> hwset; // \_____ Capture both firmware and hardware triggered events
        error_internal_intr_count_incr_r.pulse -> next     = error_internal_intr_r.error_internal_sts -> next;  // /      as a pulse to increment the intr_count_r register
        error_internal_intr_count_incr_r.pulse -> we       = error_internal_intr_r.error_internal_sts -> next;  // Generate a pulse from SW trigger, if set, or default to use the hwset input
        error_internal_intr_count_incr_r.pulse -> decr     = error_internal_intr_count_incr_r.pulse; // Auto-clear to generate pulse output
        error_internal_intr_count_r.cnt        -> incr     = error_internal_intr_count_incr_r.pulse; // Increment coincides with rising edge of interrupt sts bit

        notif_cmd_done_intr_count_incr_r.pulse -> hwset    = notif_internal_intr_r.notif_cmd_done_sts -> hwset; // \_____ Capture both firmware and hardware triggered events
        notif_cmd_done_intr_count_incr_r.pulse -> next     = notif_internal_intr_r.notif_cmd_done_sts -> next;  // /      as a pulse to increment the intr_count_r register
        notif_cmd_done_intr_count_incr_r.pulse -> we       = notif_internal_intr_r.notif_cmd_done_sts -> next;  // Generate a pulse from SW trigger, if set, or default to use the hwset input
        notif_cmd_done_intr_count_incr_r.pulse -> decr     = notif_cmd_done_intr_count_incr_r.pulse; // Auto-clear to generate pulse output
        notif_cmd_done_intr_count_r.cnt        -> incr     = notif_cmd_done_intr_count_incr_r.pulse; // Increment coincides with rising edge of interrupt sts bit

    };


    /* -----------------------
     * Register File instance
     * ----------------------- */
    intr_block_t intr_block_rf @0x6000;
};