// SPDX-License-Identifier: Apache-2.0
//
// Licensed under the Apache License, Version 2.0 (the "License");
// you may not use this file except in compliance with the License.
// You may obtain a copy of the License at
//
// http://www.apache.org/licenses/LICENSE-2.0
//
// Unless required by applicable law or agreed to in writing, software
// distributed under the License is distributed on an "AS IS" BASIS,
// WITHOUT WARRANTIES OR CONDITIONS OF ANY KIND, either express or implied.
// See the License for the specific language governing permissions and
// limitations under the License.
//


addrmap hmac256_reg {
    desc="address maps for HMAC256 register space";

    addressing = compact;
    lsb0 = true; // lsb0 property is implicit/default. See docs for
                 // SystemRDL 2.0 sections 9.1 and 13.4

    default regwidth = 32; // reg property
    default accesswidth = 32; // reg property

    default hw = na;
    signal {activelow; async; cpuif_reset; field_reset;} reset_b;
    signal {activelow; async;} error_reset_b; // Driven by Caliptra pwrgood from SoC

    /* -----------------------
    * Register definitive definitions
    * ----------------------- */

    /* ---- HMAC256 Component Name ---- */
    reg {
        name = "HMAC256 component name register type definition";
        desc = "Two 32-bit read-only registers representing of the name
                of HMAC256 component.";

        default sw = r;
        default hw = w;
        field {desc = "Name field";} NAME[32];

    } HMAC256_NAME[2] @0x00000000;



    /* ---- HMAC256 Component Version ---- */
    reg {
        name = "HMAC256 component version register type definition";
        desc = "Two 32-bit read-only registers representing of the version
                of HMAC256 component.";

        default sw = r;
        default hw = w;
        field {desc = "Version field";} VERSION[32];

    } HMAC256_VERSION[2] @0x00000008;



    /* ---- HMAC256 Component Control ---- */
    reg {
        name = "HMAC256 CTRL";
        desc = "HMAC256 component control register type definition.";

        default sw = w;
        default hw = r;
        default resetsignal = reset_b;
        field {desc = "Control init command bit: Trigs the HMAC256 core to start the
                                processing for the key and the first padded
                                message block.
                                [br] Software write generates only a single-cycle pulse on the
                                hardware interface and then will be erased"; singlepulse; swwe;} INIT = 1'b0;
        field {desc = "Control next command bit: ​Trigs the HMAC256 core to start the
                                processing for the remining padded message block.
                                [br] Software write generates only a single-cycle pulse on the
                                hardware interface and then will be erased"; singlepulse; swwe;} NEXT = 1'b0;
        field {desc = "Zeroize all internal registers: Zeroize all internal registers after HMAC process, to avoid SCA leakage.
                                [br] Software write generates only a single-cycle pulse on the
                                hardware interface and then will be erased"; singlepulse;} ZEROIZE = 1'b0;
        field {desc = "Control mode command bit: Selects the SHA-2 variant used by
                                 the HMAC256 core:
                                 0 for HMAC-SHA-224
                                 1 for HMAC-SHA-256"; swwe;} MODE = 1'b1;
        field {desc = "Control last command bit: Marks the current INIT or NEXT
                                command as the final message block. When set together
                                with INIT or NEXT, the HMAC256 core completes the OPAD
                                + final hash and produces the HMAC tag.
                                [br] Software write generates only a single-cycle pulse on the
                                hardware interface and then will be erased"; singlepulse; swwe;} LAST = 1'b0;
        field {desc = "Control restore command bit: Resumes HMAC processing from a
                                saved intermediate inner-SHA chaining state. SW writes the
                                previously-captured TAG back to HMAC256_TAG, re-supplies the
                                same MODE/KEY, then asserts RESTORE together with LAST, NEXT, or NEXT|LAST.
                                RESTORE skips ENTROPY/IPAD and loads the SHA core with TAG as the inner chaining state
                                before processing BLOCK.
                                [br] Software write generates only a single-cycle pulse on the
                                hardware interface and then will be erased"; singlepulse; swwe;} RESTORE = 1'b0;

    } HMAC256_CTRL @0x00000010;



    /* ---- HMAC256 Component Status ---- */
    reg {
        name = "HMAC256 STATUS";
        desc = "HMAC256 component status register type definition";

        default sw = r;
        default hw = w;
        default resetsignal = reset_b;
        field {desc = "Status ready bit: ​Indicates if the core is ready to take
                                a control command and process the block.";} READY = 1'b0;
        field {desc = "Status valid bit: ​Indicates if the process is done and the
                                results stored in TAG registers are valid.";} VALID = 1'b0;

    } HMAC256_STATUS @0x00000018;



    /* ---- HMAC256 Component Input Key ---- */
    reg {
        name = "HMAC256 KEY";
        desc = "HMAC256 component key register type definition
                16 32-bit registers storing the 512-bit key in big-endian representation.";

        default sw = w;
        default hw = rw;
        default we = true;
        default resetsignal = reset_b;
        field {desc = "Input HMAC key field"; hwclr;} KEY[32] = 32'b0;

    } HMAC256_KEY[16] @0x00000040;



    /* ---- HMAC256 Component Input Message Block ---- */
    reg {
        name = "HMAC256 BLOCK";
        desc = "HMAC256 component block register type definition
                16 32-bit registers storing the 512-bit padded input in big-endian representation.";

        default sw = w;
        default hw = rw;
        default we = true;
        default resetsignal = reset_b;
        field {desc = "Input message block field"; hwclr;} BLOCK[32] = 32'b0;

    } HMAC256_BLOCK[16] @0x00000080;



    /* ---- HMAC256 Component Output Tag ---- */
    reg {
        name = "HMAC256 TAG";
        desc = "HMAC256 component tag register type definition
                8 32-bit registers storing the 256-bit digest output in big-endian representation.";

        default sw = rw;
        default hw = rw;
        default we = true;
        default resetsignal = reset_b;
        field {desc = "Output tag field"; hwclr;} TAG[32] = 32'b0;

    } HMAC256_TAG[8] @0x000000C0;


    /* ---- HMAC256 Component Input LFSR Seed ---- */
    reg {
        name = "HMAC256 LFSR SEED";
        desc = "HMAC256 component lfsr seed register type definition
                6 32-bit registers storing the 192-bit lfsr seed input.";

        default sw = w;
        default hw = r;
        default resetsignal = reset_b;
        field {desc = "Input lfsr seed field";} LFSR_SEED[32] = 32'h0;

    } HMAC256_LFSR_SEED[3] @0x000000E0;



    /* ---- Global Interrupt Enable ---- */
    reg global_intr_en_t {
        name = "Per-Type Interrupt Enable Register";
        desc = "Dedicated register with one bit for each event type that may produce an interrupt.";

        default hw = na;
        default sw = rw;

        // Global enablement (for interrupts of the event types defined for this module)
        field {desc = "Global enable bit for all events of type 'Error'";       } error_en = 1'b0;
        field {desc = "Global enable bit for all events of type 'Notification'";} notif_en = 1'b0;
    };

    /* ---- Error Interrupt Enable ---- */
    reg error_intr_en_t {
        name = "Per-Event Interrupt Enable Register";
        desc = "Dedicated register with one bit for each event that may produce an interrupt.";

        default hw = na;
        default sw = rw;

        // error0 is driven by invalid CTRL writes (LAST-alone or RESTORE-alone).
        // error1/error2/error3 are reserved slots with no hardware source.
        field {desc = "Enable bit for invalid CTRL command (LAST-alone or RESTORE-alone)";} error0_en = 1'b0;
        field {desc = "Reserved enable bit (no hardware source)";} error1_en = 1'b0;
        field {desc = "Reserved enable bit (no hardware source)";} error2_en = 1'b0;
        field {desc = "Reserved enable bit (no hardware source)";} error3_en = 1'b0;
    };

    /* ---- Notification Interrupt Enable ---- */
    reg notif_intr_en_t {
        name = "Per-Event Interrupt Enable Register";
        desc = "Dedicated register with one bit for each event that may produce an interrupt.";

        default hw = na;
        default sw = rw;

        // Specific enables for the events defined in this
        // event type in the instantiating peripheral.
        field {desc = "Enable bit for Command Done Interrupt";} notif_cmd_done_en = 1'b0;
    };

    /* ---- Error Interrupt Status ---- */
    reg error_intr_t {
        name = "Interrupt Status Register type definition";
        desc = "Single bit indicating occurrence of each interrupt event.
                Sticky, level assertion, write-1-to-clear.";

        default precedence = hw;
        default hw = w;
        default hwset = true;
        default sw = rw;
        default woclr = true;
        default level intr;

        // error0 is driven by invalid CTRL writes (LAST-alone or RESTORE-alone).
        // error1/error2/error3 are reserved slots with no hardware source.
        field {desc = "Interrupt status bit set when an illegal CTRL encoding is written (e.g., LAST-only, RESTORE-only, INIT|NEXT, INIT|RESTORE)";} error0_sts = 1'b0;
        field {desc = "Reserved status bit (no hardware source)";} error1_sts = 1'b0;
        field {desc = "Reserved status bit (no hardware source)";} error2_sts = 1'b0;
        field {desc = "Reserved status bit (no hardware source)";} error3_sts = 1'b0;
    };

    /* ---- Notification Interrupt Status ---- */
    reg notif_intr_t {
        name = "Interrupt Status Register type definition";
        desc = "Single bit indicating occurrence of each interrupt event.
                Sticky, level assertion, write-1-to-clear.";

        default precedence = hw;
        default hw = w;
        default hwset = true;
        default sw = rw;
        default woclr = true;
        default level intr;

        field {desc = "Command Done Interrupt status bit";} notif_cmd_done_sts = 1'b0;
    };

    /* ---- Aggregated Interrupt Status ---- */
    reg global_intr_t {
        name = "Interrupt Status Aggregation Register type definition";
        desc = "Single bit indicating occurrence of any interrupt event
                of a given type. E.g. Notifications and Errors may drive
                to two separate interrupt registers. There may be
                multiple sources of Notifications or Errors that are
                aggregated into a single interrupt pin for that
                respective type. That pin feeds through this register
                in order to apply a global enablement of that interrupt
                event type.
                Nonsticky assertion.";

        default hw = w;
        default sw = r;
        default nonsticky intr;

        field {desc = "Interrupt Event Aggregation status bit";} agg_sts = 1'b0;
    };

    /* ---- Error Interrupt Trigger ---- */
    reg error_intr_trig_t {
        name = "Interrupt Trigger Register type definition";
        desc = "Single bit for each interrupt event allows SW to manually
                trigger occurrence of that event. Upon SW write, the trigger bit
                will pulse for 1 cycle then clear to 0. The pulse on the
                trigger register bit results in the corresponding interrupt
                status bit being set to 1.";

        default hw = na;
        default sw = rw;
        default woset = true;
        default singlepulse = true;

        // Instantiate triggers bit-by-bit.
        field {desc = "Interrupt Trigger 0 bit (invalid CTRL command)";} error0_trig = 1'b0;
        field {desc = "Reserved trigger bit (no hardware source)";} error1_trig = 1'b0;
        field {desc = "Reserved trigger bit (no hardware source)";} error2_trig = 1'b0;
        field {desc = "Reserved trigger bit (no hardware source)";} error3_trig = 1'b0;
    };

    /* ---- Notification Interrupt Trigger ---- */
    reg notif_intr_trig_t {
        name = "Interrupt Trigger Register type definition";
        desc = "Single bit for each interrupt event allows SW to manually
                trigger occurrence of that event. Upon SW write, the trigger bit
                will pulse for 1 cycle then clear to 0. The pulse on the
                trigger register bit results in the corresponding interrupt
                status bit being set to 1.";

        default hw = na;
        default sw = rw;
        default woset = true;
        default singlepulse = true;

        // Instantiate triggers bit-by-bit.
        field {desc = "Interrupt Trigger 0 bit";} notif_cmd_done_trig = 1'b0;
    };

    /* ---- Interrupt Statistics Counter Incrementor ---- */
    reg intr_count_incr_t {
        name = "Interrupt Event Count Incrementor";
        desc = "Trigger the event counter to increment based on observing
                the rising edge of an interrupt event input from the
                Hardware. The same input signal that causes an interrupt
                event to be set (sticky) also causes this signal to pulse
                for 1 clock cycle, resulting in the event counter
                incrementing by 1 for every interrupt event.
                This is implemented as a down-counter (1-bit) that will
                decrement immediately on being set - resulting in a pulse";

        default hw = w;
        default sw = r; // Has to have some access.... ideally SW wouldn't even see this
        default hwset = true;
        default decrvalue = 1;
        default counter;

        field {desc = "Pulse mirrors interrupt event occurrence";} pulse = 1'b0;
    };

    /* ---- Interrupt Statistics Counter ---- */
    reg intr_count_t {
        name = "Interrupt Event Counter";
        desc = "Provides statistics about the number of events that have
                occurred.
                Will not overflow ('incrsaturate').";

        default sw = rw;
        default hw = na;
        default incrvalue = 1;
        default incrsaturate = true;
        default counter;

        field {desc = "Count field";} cnt[32] = 32'h0;
    };


    /* -----------------------
     * Register File definitive definition
     * ----------------------- */

    // Notifications are non-error events that occur during normal operation of the module.
    // E.g. a completion of a job may produce a notification.
    // Error and notification events are separated into separate status/trigger registers
    // to allow effective priority allocation by software
    regfile intr_block_t {
        name = "Interrupt Register Block";
        desc = "Set of registers to implement interrupt functionality";

        /* ------------------------------------------------- Registers ------------------------------------------------- */
        // First 9 registers are static and always defined                                                               //
        global_intr_en_t  global_intr_en_r;      /* 1-bit per event type */                                              //
        error_intr_en_t   error_intr_en_r;       /* 1-bit per error */                                                   //
        notif_intr_en_t   notif_intr_en_r;       /* 1-bit per notification */                                            //
        global_intr_t     error_global_intr_r;   /* 1-bit aggregating all error interrupts with global enable */         //
        global_intr_t     notif_global_intr_r;   /* 1-bit aggregating all notification interrupts with global enable */  //
        error_intr_t      error_internal_intr_r; /* Error pending, SW write 1 to clear */                                //
        notif_intr_t      notif_internal_intr_r; /* Notification pending, SW write 1 to clear */                         //
        error_intr_trig_t error_intr_trig_r;     /* SW sets error bit for interrupt testing */                           //
        notif_intr_trig_t notif_intr_trig_r;     /* SW sets notification bit for interrupt testing */                    //
                                                                                                                         //
        // Align this set of registers; number of counters is based on peripheral event requirements                     //
        intr_count_t      error0_intr_count_r @0x100;                /* Reserved */                                      //
        intr_count_t      error1_intr_count_r;                       /* Reserved */                                      //
        intr_count_t      error2_intr_count_r;                       /* Per error */                                     //
        intr_count_t      error3_intr_count_r;                       /* Per error */                                     //
        intr_count_t      notif_cmd_done_intr_count_r @0x180;        /* Per notification */                              //
        //                                                                                                                          //
        // These registers should be treated by SW as reserved, and ignored.                                             //
        // Offset at 0x200 gives enough space for 32 Errors and 32 Notifications                                         //
        // to be implemented (requiring 2*32 32-bit registers starting at                                                //
        // offset 0x100), and still allowing the entire regfile to fit                                                   //
        // inside a 1024-byte space.                                                                                     //
        intr_count_incr_t error0_intr_count_incr_r @0x200;           /* Reserved */                                      //
        intr_count_incr_t error1_intr_count_incr_r;                  /* Reserved */                                      //
        intr_count_incr_t error2_intr_count_incr_r;                  /* Per error count incrementor pulse */             //
        intr_count_incr_t error3_intr_count_incr_r;                  /* Per error count incrementor pulse */             //
        intr_count_incr_t notif_cmd_done_intr_count_incr_r;          /* Per notification count incrementor pulse */      //
        /* ------------------------------------------------------------------------------------------------------------- */

        /* ---- Reset assignment for Error Events ---- */
        error_internal_intr_r.error0_sts -> resetsignal = error_reset_b;
        error_internal_intr_r.error1_sts -> resetsignal = error_reset_b;
        error_internal_intr_r.error2_sts -> resetsignal = error_reset_b;
        error_internal_intr_r.error3_sts -> resetsignal = error_reset_b;
        error0_intr_count_r.cnt          -> resetsignal = error_reset_b;
        error1_intr_count_r.cnt          -> resetsignal = error_reset_b;
        error2_intr_count_r.cnt          -> resetsignal = error_reset_b;
        error3_intr_count_r.cnt          -> resetsignal = error_reset_b;

        /* ---- Interrupt Event Dynamic Assignments ---- */
        error_internal_intr_r.error0_sts -> enable = error_intr_en_r.error0_en;
        error_internal_intr_r.error1_sts -> enable = error_intr_en_r.error1_en;
        error_internal_intr_r.error2_sts -> enable = error_intr_en_r.error2_en;
        error_internal_intr_r.error3_sts -> enable = error_intr_en_r.error3_en;
        notif_internal_intr_r.notif_cmd_done_sts -> enable = notif_intr_en_r.notif_cmd_done_en;

        error_internal_intr_r.error0_sts -> next   = error_intr_trig_r.error0_trig;
        error_internal_intr_r.error1_sts -> next   = error_intr_trig_r.error1_trig;
        error_internal_intr_r.error2_sts -> next   = error_intr_trig_r.error2_trig;
        error_internal_intr_r.error3_sts -> next   = error_intr_trig_r.error3_trig;
        notif_internal_intr_r.notif_cmd_done_sts -> next   = notif_intr_trig_r.notif_cmd_done_trig;

        // NOTE: hwset for events is implicitly defined as module input

        /* ---- Global Interrupt Dynamic Assignments ---- */
        error_global_intr_r.agg_sts -> enable = global_intr_en_r.error_en;
        notif_global_intr_r.agg_sts -> enable = global_intr_en_r.notif_en;

        error_global_intr_r.agg_sts -> next = error_internal_intr_r -> intr;
        notif_global_intr_r.agg_sts -> next = notif_internal_intr_r -> intr;

        /* ---- Event Statistics Tracker Assignments ---- */
        error0_intr_count_incr_r.pulse -> hwset    = error_internal_intr_r.error0_sts -> hwset;
        error0_intr_count_incr_r.pulse -> next     = error_internal_intr_r.error0_sts -> next;
        error0_intr_count_incr_r.pulse -> we       = error_internal_intr_r.error0_sts -> next;
        error0_intr_count_incr_r.pulse -> decr     = error0_intr_count_incr_r.pulse;
        error0_intr_count_r.cnt        -> incr     = error0_intr_count_incr_r.pulse;

        error1_intr_count_incr_r.pulse -> hwset    = error_internal_intr_r.error1_sts -> hwset;
        error1_intr_count_incr_r.pulse -> next     = error_internal_intr_r.error1_sts -> next;
        error1_intr_count_incr_r.pulse -> we       = error_internal_intr_r.error1_sts -> next;
        error1_intr_count_incr_r.pulse -> decr     = error1_intr_count_incr_r.pulse;
        error1_intr_count_r.cnt        -> incr     = error1_intr_count_incr_r.pulse;

        error2_intr_count_incr_r.pulse -> hwset    = error_internal_intr_r.error2_sts -> hwset;
        error2_intr_count_incr_r.pulse -> next     = error_internal_intr_r.error2_sts -> next;
        error2_intr_count_incr_r.pulse -> we       = error_internal_intr_r.error2_sts -> next;
        error2_intr_count_incr_r.pulse -> decr     = error2_intr_count_incr_r.pulse;
        error2_intr_count_r.cnt        -> incr     = error2_intr_count_incr_r.pulse;

        error3_intr_count_incr_r.pulse -> hwset    = error_internal_intr_r.error3_sts -> hwset;
        error3_intr_count_incr_r.pulse -> next     = error_internal_intr_r.error3_sts -> next;
        error3_intr_count_incr_r.pulse -> we       = error_internal_intr_r.error3_sts -> next;
        error3_intr_count_incr_r.pulse -> decr     = error3_intr_count_incr_r.pulse;
        error3_intr_count_r.cnt        -> incr     = error3_intr_count_incr_r.pulse;

        notif_cmd_done_intr_count_incr_r.pulse -> hwset    = notif_internal_intr_r.notif_cmd_done_sts -> hwset;
        notif_cmd_done_intr_count_incr_r.pulse -> next     = notif_internal_intr_r.notif_cmd_done_sts -> next;
        notif_cmd_done_intr_count_incr_r.pulse -> we       = notif_internal_intr_r.notif_cmd_done_sts -> next;
        notif_cmd_done_intr_count_incr_r.pulse -> decr     = notif_cmd_done_intr_count_incr_r.pulse;
        notif_cmd_done_intr_count_r.cnt        -> incr     = notif_cmd_done_intr_count_incr_r.pulse;

    };

    /* -----------------------
     * Register File instance
     * ----------------------- */
    intr_block_t intr_block_rf @0x800;

};
