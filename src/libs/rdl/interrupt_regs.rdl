// NOTE: Interrupts are classified according to "Type" in this file.
//        - The two Types assumed are "Error" and "Notification", but
//          more could be instantiated.
//        - 1 Output Interrupt pin exists for each Type.
addrmap interrupt_regs {


    /* -----------------------
     * Default properties for Address Region
     * ----------------------- */

    desc = "Address map section for peripheral interrupt support
            implementation - these registers should be added (keeping
            the same offsets) to the full peripheral reg file";
    addressing = compact;
    lsb0 = true; // lsb0 property is implicit/default. See docs for
                 // SystemRDL 2.0 sections 9.1 and 13.4

    default regwidth = 32; // reg property
    default accesswidth = 32; // reg property
    default hw = na; // field property


    /* -----------------------
     * Signal anonymous definitions
     * ----------------------- */

    /* ---- Reset ---- */
    signal {activelow; async; cpuif_reset; field_reset;} reset_b;
    signal {activelow; async;} error_reset_b; // Driven by Caliptra pwrgood from SoC


    /* -----------------------
     * Register definitive definitions
     * ----------------------- */

    /* ---- Global Interrupt Enable ---- */
    reg global_intr_en_t {
        name = "Per-Type Interrupt Enable Register";
        desc = "Dedicated register with one bit for each event type that may produce an interrupt.";

        default hw = na;
        default sw = rw;

        // Global enablement (for interrupts of the event types defined for this module)
        field {desc = "Global enable bit for all events of type 'Error'";       } error_en = 1'b0;
        field {desc = "Global enable bit for all events of type 'Notification'";} notif_en = 1'b0;
    };

    /* ---- Error Interrupt Enable ---- */
    reg error_intr_en_t {
        name = "Per-Event Interrupt Enable Register";
        desc = "Dedicated register with one bit for each event that may produce an interrupt.";

        default hw = na;
        default sw = rw;

        // Specific enables for the events defined in this
        // event type in the instantiating peripheral.
        field {desc = "Enable bit for Event 0";} error0_en = 1'b0;
        field {desc = "Enable bit for Event 1";} error1_en = 1'b0;
        field {desc = "Enable bit for Event 2";} error2_en = 1'b0;
        field {desc = "Enable bit for Event 3";} error3_en = 1'b0;
    };

    /* ---- Notification Interrupt Enable ---- */
    reg notif_intr_en_t {
        name = "Per-Event Interrupt Enable Register";
        desc = "Dedicated register with one bit for each event that may produce an interrupt.";

        default hw = na;
        default sw = rw;

        // Specific enables for the events defined in this
        // event type in the instantiating peripheral.
        field {desc = "Enable bit for Event 0";} notif0_en = 1'b0;
        field {desc = "Enable bit for Event 1";} notif1_en = 1'b0;
        field {desc = "Enable bit for Event 2";} notif2_en = 1'b0;
        field {desc = "Enable bit for Event 3";} notif3_en = 1'b0;
    };

    /* ---- Error Interrupt Status ---- */
    reg error_intr_t {
        name = "Interrupt Status Register type definition";
        desc = "Single bit indicating occurrence of each interrupt event.
                Sticky, level assertion, write-1-to-clear.";

        default precedence = hw;
        default hw = w;
        default hwset = true;
        default sw = rw;
        default woclr = true;
        default level intr;

        field {desc = "Interrupt Event 0 status bit";} error0_sts = 1'b0;
        field {desc = "Interrupt Event 1 status bit";} error1_sts = 1'b0;
        field {desc = "Interrupt Event 2 status bit";} error2_sts = 1'b0;
        field {desc = "Interrupt Event 3 status bit";} error3_sts = 1'b0;
    };

    /* ---- Notification Interrupt Status ---- */
    reg notif_intr_t {
        name = "Interrupt Status Register type definition";
        desc = "Single bit indicating occurrence of each interrupt event.
                Sticky, level assertion, write-1-to-clear.";

        default precedence = hw;
        default hw = w;
        default hwset = true;
        default sw = rw;
        default woclr = true;
        default level intr;

        field {desc = "Interrupt Event 0 status bit";} notif0_sts = 1'b0;
        field {desc = "Interrupt Event 1 status bit";} notif1_sts = 1'b0;
        field {desc = "Interrupt Event 2 status bit";} notif2_sts = 1'b0;
        field {desc = "Interrupt Event 3 status bit";} notif3_sts = 1'b0;
    };

    /* ---- Aggregated Interrupt Status ---- */
    reg global_intr_t {
        name = "Interrupt Status Aggregation Register type definition";
        desc = "Single bit indicating occurrence of any interrupt event
                of a given type. E.g. Notifications and Errors may drive
                to two separate interrupt registers. There may be
                multiple sources of Notifications or Errors that are
                aggregated into a single interrupt pin for that
                respective type. That pin feeds through this register
                in order to apply a global enablement of that interrupt
                event type.
                Nonsticky assertion.";

        default hw = w;
        default sw = r;
        default nonsticky intr;

        field {desc = "Interrupt Event Aggregation status bit";} agg_sts = 1'b0;
    };

    /* ---- Error Interrupt Trigger ---- */
    reg error_intr_trig_t {
        name = "Interrupt Trigger Register type definition";
        desc = "Single bit for each interrupt event allows SW to manually
                trigger occurrence of that event. Upon SW write, the trigger bit
                will pulse for 1 cycle then clear to 0. The pulse on the
                trigger register bit results in the corresponding interrupt
                status bit being set to 1.";

        default hw = na;
        default sw = rw;
        default woset = true;
        default singlepulse = true;

        // Instantiate triggers bit-by-bit.
        field {desc = "Interrupt Trigger 0 bit";} error0_trig = 1'b0;
        field {desc = "Interrupt Trigger 1 bit";} error1_trig = 1'b0;
        field {desc = "Interrupt Trigger 2 bit";} error2_trig = 1'b0;
        field {desc = "Interrupt Trigger 3 bit";} error3_trig = 1'b0;
    };

    /* ---- Notification Interrupt Trigger ---- */
    reg notif_intr_trig_t {
        name = "Interrupt Trigger Register type definition";
        desc = "Single bit for each interrupt event allows SW to manually
                trigger occurrence of that event. Upon SW write, the trigger bit
                will pulse for 1 cycle then clear to 0. The pulse on the
                trigger register bit results in the corresponding interrupt
                status bit being set to 1.";

        default hw = na;
        default sw = rw;
        default woset = true;
        default singlepulse = true;

        // Instantiate triggers bit-by-bit.
        field {desc = "Interrupt Trigger 0 bit";} notif0_trig = 1'b0;
        field {desc = "Interrupt Trigger 1 bit";} notif1_trig = 1'b0;
        field {desc = "Interrupt Trigger 2 bit";} notif2_trig = 1'b0;
        field {desc = "Interrupt Trigger 3 bit";} notif3_trig = 1'b0;
    };

    /* ---- Interrupt Statistics Counter Incrementor ---- */
    reg intr_count_incr_t {
        name = "Interrupt Event Count Incrementor";
        desc = "Trigger the event counter to increment based on observing
                the rising edge of an interrupt event input from the
                Hardware. The same input signal that causes an interrupt
                event to be set (sticky) also causes this signal to pulse
                for 1 clock cycle, resulting in the event counter
                incrementing by 1 for every interrupt event.
                This is implemented as a down-counter (1-bit) that will
                decrement immediately on being set - resulting in a pulse";

        default hw = w;
        default sw = r; // Has to have some access.... ideally SW wouldn't even see this
        default hwset = true;
        default decrvalue = 1;
        default counter;

        field {desc = "Pulse mirrors interrupt event occurrence";} pulse = 1'b0;
    };

    /* ---- Interrupt Statistics Counter ---- */
    reg intr_count_t {
        name = "Interrupt Event Counter";
        desc = "Provides statistics about the number of events that have
                occurred.
                Will not overflow ('incrsaturate').";

        default sw = rw;
        default hw = na;
        default incrvalue = 1;
        default incrsaturate = true;
        default counter;

        field {desc = "Count field";} cnt[32] = 32'h0;
    };


    /* -----------------------
     * Register File definitive definition
     * ----------------------- */

    // Notifications are non-error events that occur during normal operation of the module.
    // E.g. a completion of a job may produce a notification.
    // Error and notification events are separated into separate status/trigger registers
    // to allow effective priority allocation by software
    regfile intr_block_t {
        name = "Interrupt Register Block";
        desc = "Set of registers to implement interrupt functionality";

        /* ------------------------------------------------- Registers ------------------------------------------------- */
        // First 9 registers are static and always defined                                                               //
        global_intr_en_t  global_intr_en_r;      /* 1-bit per event type */                                              //
        error_intr_en_t   error_intr_en_r;       /* 1-bit per error */                                                   //
        notif_intr_en_t   notif_intr_en_r;       /* 1-bit per notification */                                            //
        global_intr_t     error_global_intr_r;   /* 1-bit aggregating all error interrupts with global enable */         //
        global_intr_t     notif_global_intr_r;   /* 1-bit aggregating all notification interrupts with global enable */  //
        error_intr_t      error_internal_intr_r; /* Error pending, SW write 1 to clear */                                //
        notif_intr_t      notif_internal_intr_r; /* Notification pending, SW write 1 to clear */                         //
        error_intr_trig_t error_intr_trig_r;     /* SW sets error bit for interrupt testing */                           //
        notif_intr_trig_t notif_intr_trig_r;     /* SW sets notification bit for interrupt testing */                    //
                                                                                                                         //
        // Align this set of registers; number of counters is based on peripheral event requirements                     //
        intr_count_t      error0_intr_count_r @0x100;  /* Per error */                                                   //
        intr_count_t      error1_intr_count_r;         /* Per error */                                                   //
        intr_count_t      error2_intr_count_r;         /* Per error */                                                   //
        intr_count_t      error3_intr_count_r;         /* Per error */                                                   //
        intr_count_t      notif0_intr_count_r @0x180;  /* Per notification */                                            //
        intr_count_t      notif1_intr_count_r;         /* Per notification */                                            //
        intr_count_t      notif2_intr_count_r;         /* Per notification */                                            //
        intr_count_t      notif3_intr_count_r;         /* Per notification */                                            //
                                                                                                                         //
        // These registers should be treated by SW as reserved, and ignored.                                             //
        // Offset at 0x200 gives enough space for 32 Errors and 32 Notifications                                         //
        // to be implemented (requiring 2*32 32-bit registers starting at                                                //
        // offset 0x100), and still allowing the entire regfile to fit                                                   //
        // inside a 1024-byte space.                                                                                     //
        intr_count_incr_t error0_intr_count_incr_r @0x200; /* Per error count incrementor pulse */                       //
        intr_count_incr_t error1_intr_count_incr_r;        /* Per error count incrementor pulse */                       //
        intr_count_incr_t error2_intr_count_incr_r;        /* Per error count incrementor pulse */                       //
        intr_count_incr_t error3_intr_count_incr_r;        /* Per error count incrementor pulse */                       //
        intr_count_incr_t notif0_intr_count_incr_r;        /* Per notification count incrementor pulse */                //
        intr_count_incr_t notif1_intr_count_incr_r;        /* Per notification count incrementor pulse */                //
        intr_count_incr_t notif2_intr_count_incr_r;        /* Per notification count incrementor pulse */                //
        intr_count_incr_t notif3_intr_count_incr_r;        /* Per notification count incrementor pulse */                //
        /* ------------------------------------------------------------------------------------------------------------- */

        /* ---- Reset assignment for Error Events ---- */
        error_internal_intr_r.error0_sts -> resetsignal = error_reset_b;
        error_internal_intr_r.error1_sts -> resetsignal = error_reset_b;
        error_internal_intr_r.error2_sts -> resetsignal = error_reset_b;
        error_internal_intr_r.error3_sts -> resetsignal = error_reset_b;
        error0_intr_count_r.cnt          -> resetsignal = error_reset_b;
        error1_intr_count_r.cnt          -> resetsignal = error_reset_b;
        error2_intr_count_r.cnt          -> resetsignal = error_reset_b;
        error3_intr_count_r.cnt          -> resetsignal = error_reset_b;
        // TODO: Use this same reset for the error incrementor pulse too?

        /* ---- Interrupt Event Dynamic Assignments ---- */
        error_internal_intr_r.error0_sts -> enable = error_intr_en_r.error0_en;
        error_internal_intr_r.error1_sts -> enable = error_intr_en_r.error1_en;
        error_internal_intr_r.error2_sts -> enable = error_intr_en_r.error2_en;
        error_internal_intr_r.error3_sts -> enable = error_intr_en_r.error3_en;
        notif_internal_intr_r.notif0_sts -> enable = notif_intr_en_r.notif0_en;
        notif_internal_intr_r.notif1_sts -> enable = notif_intr_en_r.notif1_en;
        notif_internal_intr_r.notif2_sts -> enable = notif_intr_en_r.notif2_en;
        notif_internal_intr_r.notif3_sts -> enable = notif_intr_en_r.notif3_en;

        error_internal_intr_r.error0_sts -> next   = error_intr_trig_r.error0_trig;
        error_internal_intr_r.error1_sts -> next   = error_intr_trig_r.error1_trig;
        error_internal_intr_r.error2_sts -> next   = error_intr_trig_r.error2_trig;
        error_internal_intr_r.error3_sts -> next   = error_intr_trig_r.error3_trig;
        notif_internal_intr_r.notif0_sts -> next   = notif_intr_trig_r.notif0_trig;
        notif_internal_intr_r.notif1_sts -> next   = notif_intr_trig_r.notif1_trig;
        notif_internal_intr_r.notif2_sts -> next   = notif_intr_trig_r.notif2_trig;
        notif_internal_intr_r.notif3_sts -> next   = notif_intr_trig_r.notif3_trig;

        // NOTE: hwset for events is implicitly defined as module input

        /* ---- Global Interrupt Dynamic Assignments ---- */
        error_global_intr_r.agg_sts -> enable = global_intr_en_r.error_en;
        notif_global_intr_r.agg_sts -> enable = global_intr_en_r.notif_en;

        error_global_intr_r.agg_sts -> next = error_internal_intr_r -> intr;
        notif_global_intr_r.agg_sts -> next = notif_internal_intr_r -> intr;

        /* ---- Event Statistics Tracker Assignments ---- */
        // NOTE: This method relies upon a "counter" that is set using the
        //       same events that trigger an interrupt, then immediately
        //       self-clearing, which results in a pulse. Must be configured
        //       to be sensitive to the interrupt trigger events for each event.
        //       The output pulse is then used to increment the ACTUAL counter
        error0_intr_count_incr_r.pulse -> hwset    = error_internal_intr_r.error0_sts -> hwset; // \_____ Capture both firmware and hardware triggered events
        error0_intr_count_incr_r.pulse -> next     = error_internal_intr_r.error0_sts -> next;  // /      as a pulse to increment the intr_count_r register
        error0_intr_count_incr_r.pulse -> we       = error_internal_intr_r.error0_sts -> next;  // Generate a pulse from SW trigger, if set, or default to use the hwset input
        error0_intr_count_incr_r.pulse -> decr     = error0_intr_count_incr_r.pulse; // Auto-clear to generate pulse output
        error0_intr_count_r.cnt        -> incr     = error0_intr_count_incr_r.pulse; // Increment coincides with rising edge of interrupt sts bit

        error1_intr_count_incr_r.pulse -> hwset    = error_internal_intr_r.error1_sts -> hwset; // \_____ Capture both firmware and hardware triggered events
        error1_intr_count_incr_r.pulse -> next     = error_internal_intr_r.error1_sts -> next;  // /      as a pulse to increment the intr_count_r register
        error1_intr_count_incr_r.pulse -> we       = error_internal_intr_r.error1_sts -> next;  // Generate a pulse from SW trigger, if set, or default to use the hwset input
        error1_intr_count_incr_r.pulse -> decr     = error1_intr_count_incr_r.pulse; // Auto-clear to generate pulse output
        error1_intr_count_r.cnt        -> incr     = error1_intr_count_incr_r.pulse; // Increment coincides with rising edge of interrupt sts bit

        error2_intr_count_incr_r.pulse -> hwset    = error_internal_intr_r.error2_sts -> hwset; // \_____ Capture both firmware and hardware triggered events
        error2_intr_count_incr_r.pulse -> next     = error_internal_intr_r.error2_sts -> next;  // /      as a pulse to increment the intr_count_r register
        error2_intr_count_incr_r.pulse -> we       = error_internal_intr_r.error2_sts -> next;  // Generate a pulse from SW trigger, if set, or default to use the hwset input
        error2_intr_count_incr_r.pulse -> decr     = error2_intr_count_incr_r.pulse; // Auto-clear to generate pulse output
        error2_intr_count_r.cnt        -> incr     = error2_intr_count_incr_r.pulse; // Increment coincides with rising edge of interrupt sts bit

        error3_intr_count_incr_r.pulse -> hwset    = error_internal_intr_r.error3_sts -> hwset; // \_____ Capture both firmware and hardware triggered events
        error3_intr_count_incr_r.pulse -> next     = error_internal_intr_r.error3_sts -> next;  // /      as a pulse to increment the intr_count_r register
        error3_intr_count_incr_r.pulse -> we       = error_internal_intr_r.error3_sts -> next;  // Generate a pulse from SW trigger, if set, or default to use the hwset input
        error3_intr_count_incr_r.pulse -> decr     = error3_intr_count_incr_r.pulse; // Auto-clear to generate pulse output
        error3_intr_count_r.cnt        -> incr     = error3_intr_count_incr_r.pulse; // Increment coincides with rising edge of interrupt sts bit

        notif0_intr_count_incr_r.pulse -> hwset    = notif_internal_intr_r.notif0_sts -> hwset; // \_____ Capture both firmware and hardware triggered events
        notif0_intr_count_incr_r.pulse -> next     = notif_internal_intr_r.notif0_sts -> next;  // /      as a pulse to increment the intr_count_r register
        notif0_intr_count_incr_r.pulse -> we       = notif_internal_intr_r.notif0_sts -> next;  // Generate a pulse from SW trigger, if set, or default to use the hwset input
        notif0_intr_count_incr_r.pulse -> decr     = notif0_intr_count_incr_r.pulse; // Auto-clear to generate pulse output
        notif0_intr_count_r.cnt        -> incr     = notif0_intr_count_incr_r.pulse; // Increment coincides with rising edge of interrupt sts bit

        notif1_intr_count_incr_r.pulse -> hwset    = notif_internal_intr_r.notif1_sts -> hwset; // \_____ Capture both firmware and hardware triggered events
        notif1_intr_count_incr_r.pulse -> next     = notif_internal_intr_r.notif1_sts -> next;  // /      as a pulse to increment the intr_count_r register
        notif1_intr_count_incr_r.pulse -> we       = notif_internal_intr_r.notif1_sts -> next;  // Generate a pulse from SW trigger, if set, or default to use the hwset input
        notif1_intr_count_incr_r.pulse -> decr     = notif1_intr_count_incr_r.pulse; // Auto-clear to generate pulse output
        notif1_intr_count_r.cnt        -> incr     = notif1_intr_count_incr_r.pulse; // Increment coincides with rising edge of interrupt sts bit

        notif2_intr_count_incr_r.pulse -> hwset    = notif_internal_intr_r.notif2_sts -> hwset; // \_____ Capture both firmware and hardware triggered events
        notif2_intr_count_incr_r.pulse -> next     = notif_internal_intr_r.notif2_sts -> next;  // /      as a pulse to increment the intr_count_r register
        notif2_intr_count_incr_r.pulse -> we       = notif_internal_intr_r.notif2_sts -> next;  // Generate a pulse from SW trigger, if set, or default to use the hwset input
        notif2_intr_count_incr_r.pulse -> decr     = notif2_intr_count_incr_r.pulse; // Auto-clear to generate pulse output
        notif2_intr_count_r.cnt        -> incr     = notif2_intr_count_incr_r.pulse; // Increment coincides with rising edge of interrupt sts bit

        notif3_intr_count_incr_r.pulse -> hwset    = notif_internal_intr_r.notif3_sts -> hwset; // \_____ Capture both firmware and hardware triggered events
        notif3_intr_count_incr_r.pulse -> next     = notif_internal_intr_r.notif3_sts -> next;  // /      as a pulse to increment the intr_count_r register
        notif3_intr_count_incr_r.pulse -> we       = notif_internal_intr_r.notif3_sts -> next;  // Generate a pulse from SW trigger, if set, or default to use the hwset input
        notif3_intr_count_incr_r.pulse -> decr     = notif3_intr_count_incr_r.pulse; // Auto-clear to generate pulse output
        notif3_intr_count_r.cnt        -> incr     = notif3_intr_count_incr_r.pulse; // Increment coincides with rising edge of interrupt sts bit

    };


    /* -----------------------
     * Register File instance
     * ----------------------- */
    intr_block_t intr_block_rf;

};
